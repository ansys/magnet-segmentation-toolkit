# Ansys Electronics Desktop project, version 2023.1
materials:
  vacuum: permittivity=1
  M250-35A_20C: permeability{HUnit=A_per_meter BUnit=tesla curve (0, 0) (12, 0.1) (24, 0.2) (36, 0.3) (48, 0.4) (60, 0.5) (72, 0.6) (84, 0.7) (96, 0.8) (109, 0.9) (128, 1) (155, 1.1) (200, 1.2) (295, 1.3) (578, 1.4) (1567, 1.5) (3673, 1.6) (6996, 1.7) (13134.9088, 1.8162) (28200.2369, 1.8924) (100790, 1.998) (180370, 2.1) (259950, 2.2) (339530, 2.3) (419110, 2.4) (498690, 2.5)} conductivity=1694915.3 core_loss_type="Electrical Steel" core_loss_kh=187.425 core_loss_kc=0.34153292 mass_density=7650 stacking_type=Lamination stacking_factor=0.97 stacking_direction=V(3)
  Copper (Pure)_153.183177054828C: conductivity=38303238
  N30UH_139.999983577095C: permeability{BTypeForSingleCurve=intrinsic HUnit=A_per_meter BUnit=tesla curve (-879580.15, 0) (-879374.23, 0.011159289) (-879163.49, 0.022438134) (-878947.81, 0.033834484) (-878727.08, 0.045346124) (-878501.19, 0.056970662) (-878270.01, 0.068705531) (-878033.41, 0.080547985) (-877791.28, 0.092495092) (-877543.48, 0.10454373) (-877289.88, 0.1166906) (-877030.33, 0.12893219) (-876764.72, 0.14126481) (-876492.88, 0.15368457) (-876214.68, 0.16618736) (-875929.97, 0.17876891) (-875638.59, 0.1914247) (-875340.39, 0.20415004) (-875035.21, 0.21694004) (-874722.89, 0.22978959) (-874403.25, 0.24269338) (-874076.13, 0.25564591) (-873741.35, 0.26864147) (-873398.73, 0.28167418) (-873048.1, 0.29473793) (-872689.25, 0.30782645) (-872322, 0.32093328) (-871946.16, 0.33405176) (-871561.51, 0.3471751) (-871167.86, 0.3602963) (-870765, 0.37340822) (-870352.7, 0.38650358) (-869930.75, 0.39957493) (-869498.92, 0.41261472) (-869056.98, 0.42561526) (-868604.7, 0.43856874) (-868141.83, 0.45146728) (-867668.12, 0.4643029) (-867183.32, 0.47706755) (-866687.17, 0.48975312) (-866179.4, 0.50235148) (-865659.75, 0.51485446) (-865127.93, 0.52725388) (-864583.66, 0.53954158) (-864026.65, 0.55170944) (-863456.6, 0.56374937) (-862873.21, 0.57565337) (-862276.15, 0.5874135) (-861665.12, 0.59902196) (-861039.78, 0.61047108) (-860399.8, 0.62175332) (-859744.84, 0.63286134) (-859074.55, 0.64378799) (-858388.56, 0.65452634) (-857686.51, 0.66506969) (-856968.03, 0.67541162) (-856232.73, 0.685546) (-855480.21, 0.69546698) (-854710.07, 0.70516906) (-853921.91, 0.71464708) (-853115.29, 0.72389626) (-852289.79, 0.73291218) (-851444.96, 0.74169084) (-850580.35, 0.75022866) (-849695.5, 0.75852249) (-848789.94, 0.76656962) (-847863.18, 0.77436783) (-846914.72, 0.78191533) (-845944.05, 0.78921083) (-844950.66, 0.79625353) (-843934.01, 0.80304311) (-842893.57, 0.80957976) (-841828.76, 0.81586415) (-840739.02, 0.82189743) (-839623.78, 0.82768127) (-838482.42, 0.83321781) (-837314.34, 0.83850964) (-836118.92, 0.84355985) (-834895.51, 0.84837195) (-833643.46, 0.85294992) (-832362.09, 0.85729811) (-831050.73, 0.8614213) (-829708.66, 0.86532464) (-828335.18, 0.86901362) (-826929.54, 0.87249408) (-825491, 0.87577215) (-824018.77, 0.8788542) (-822512.08, 0.8817469) (-820970.11, 0.88445708) (-819392.05, 0.88699178) (-817777.04, 0.88935816) (-816124.22, 0.89156354) (-814432.7, 0.89361527) (-812701.59, 0.89552078) (-810929.95, 0.89728752) (-809116.83, 0.89892291) (-807261.26, 0.90043434) (-805362.25, 0.90182912) (-803418.78, 0.90311447) (-801429.82, 0.90429746) (-799394.28, 0.90538502) (-797311.1, 0.90638392) (-795179.14, 0.9073007) (-792997.28, 0.90814172) (-790764.33, 0.90891308) (-788479.1, 0.90962066) (-786140.38, 0.91027006) (-783746.9, 0.91086662) (-781297.39, 0.91141542) (-778790.53, 0.91192124) (-776224.98, 0.9123886) (-773599.37, 0.91282172) (-770912.28, 0.91322457) (-768162.3, 0.91360082) (-765347.93, 0.91395386) (-762467.67, 0.91428687) (-759519.98, 0.91460272) (-756503.28, 0.91490406) (-753415.95, 0.91519332) (-750256.35, 0.91547269)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} conductivity=555555.56 magnetic_coercivity{Magnitude=-879580.15A_per_meter DirComp1=1 DirComp2=0 DirComp3=0}

design Motor-CAD e9 (Maxwell 3D, Transient, model units mm)
variables:
  DiaGap = 132mm
  DiaStatorYoke = 198mm
  DiaShaft = 80mm
  DiaOuter = 198mm
  Airgap = 1mm
  StatorSkewAngle = 0deg
  Model_Length = 255.42977mm
  Magnet_Length = 150mm
  Stator_Lam_Length = 160mm
  Rotor_Lam_Length = 150mm
  RotorDia = 130mm
  Rotor_Slices = 1
  SlotNumber_Stator = 48
  SlotType_Stator = 3
  Hs0_Stator = 1mm
  Hs1_Stator = 0.33497334mm
  Hs2_Stator = 17.541151mm
  Bs0_Stator = 3mm
  Bs1_Stator = 4.3148444mm
  Bs2_Stator = 6.61426mm
  Rs_Stator = 2mm
  FilletType_Stator = 3
  EndWindingLength = 60.429768mm
  Layers = 1
  ParallelPaths = 2
  WdgExt_F = 5mm
  SpanExt = 30.214884mm
  HalfAxial = 1
  SymmetryFactor = 8
  SegAngle = 0deg
  SegAngle_Coil_Armature = 3.75deg
  NumPoles = 8
  Magnet_Axial_Offset = 0mm
  Axial_Segments = 6
  PoleType_VPMCore = 1
  L1_ThicknessDuct = 6.2mm
  L1_WidthDuct = 17mm
  L1_ThicknessBridge = 1mm
  L1_ExtOuter = 2mm
  L1_ExtInner = 2mm
  L1_PoleVAngle = 150deg
  L1_ArcPole = 155deg
  L1_ThicknessPost = 0.5mm
  L1_DminMag = 4.5631061mm
  L1_WidthMagnet = 16mm
  L1_InnerGapMagnet = 0.2mm
  Shaft_Hole_Diameter = 0mm
  Sleeve_Thickness = 0mm
  Banding_Thickness = 0mm
  IPeak = 297.80933A
  PhaseAdvance = 39.746164deg
  MachineRPM = 4500rpm
  NumTorqueCycles = 1
  NumTorquePointsPerCycle = 90
  DriveOffsetED = 0deg
  InitialPositionMD = -DriveOffsetED / (NumPoles/2)
geometry:
  Stator_Lamination_Primitive [M250-35A_20C] = user_primitive(RMxprt/VentSlotCore.dll, DiaGap=DiaGap, DiaYoke=DiaStatorYoke, Length=Stator_Lam_Length, Skew=StatorSkewAngle, Slots=SlotNumber_Stator, SlotType=SlotType_Stator, Hs0=Hs0_Stator, Hs01=0mm, Hs1=Hs1_Stator, Hs2=17.541151mm, Bs0=Bs0_Stator, Bs1=4.3148444mm, Bs2=6.61426mm, Rs=Rs_Stator, FilletType=FilletType_Stator, HalfSlot=0, VentHoles=0, HoleDiaIn=0mm, HoleDiaOut=0mm, HoleLocIn=0mm, HoleLocOut=0mm, VentDucts=0, DuctWidth=0mm, DuctPitch=0mm, SegAngle=SegAngle, LenRegion=0mm, InfoCore=0)
  Rotor_1 [M250-35A_20C] = polyline(z=0mm, xy in mm: (-65, 0) (-60.0521, -24.8744) (-45.9619, -45.9619) (-24.8744, -60.0521) (0, -65) (24.8744, -60.0521) (45.9619, -45.9619) (60.0521, -24.8744) (65, 0) (60.0521, 24.8744) (45.9619, 45.9619) (24.8744, 60.0521) (0, 65) (-24.8744, 60.0521) (-45.9619, 45.9619) (-60.0521, 24.8744) (-65, 0), closed, covered, Arc from point 0 over 3, Arc from point 2 over 3, Arc from point 4 over 3, Arc from point 6 over 3, Arc from point 8 over 3, Arc from point 10 over 3, Arc from point 12 over 3, Arc from point 14 over 3)
  Rotor_Subtract_12 = polyline(z=0mm, xy in mm: (-28.2842, 28.2842) (-36.9551, 15.3073) (-40, 0) (-36.9551, -15.3073) (-28.2842, -28.2842) (-15.3073, -36.9551) (0, -40) (15.3073, -36.9551) (28.2842, -28.2842) (36.9551, -15.3073) (40, 0) (36.9551, 15.3073) (28.2842, 28.2842) (15.3073, 36.9551) (0, 40) (-15.3073, 36.9551) (-28.2842, 28.2842), closed, covered, Arc from point 0 over 3, Arc from point 2 over 3, Arc from point 4 over 3, Arc from point 6 over 3, Arc from point 8 over 3, Arc from point 10 over 3, Arc from point 12 over 3, Arc from point 14 over 3)
  Rotor_1.subtract(Rotor_Subtract_12)
  Rotor_Pocket_1_8 [vacuum] = polyline(z=0mm, xy in mm: (48.6318, 16.2656) (58.372, 3.572) (58.6764, 3.1753) (62.3533, 3.4757) (63.5952, 6.9496) (63.2908, 7.3463) (58.5307, 3.6937) (48.7905, 16.3874) (53.5506, 20.0399) (53.2462, 20.4366) (49.5693, 20.1362) (48.3274, 16.6623) (48.6318, 16.2656), closed, covered, Arc from point 2 over 3, Arc from point 9 over 3)
  coordinate_system CS_L1_1Magnet1N1_1_1 = origin=(56.04069mm, 11.866879mm, (Magnet_Length / 2) + Magnet_Axial_Offset - 12.5mm) x=(0.76399928mm, 0.58623727mm, 0mm) y=(-0.58623727mm, 0.76399928mm, 0mm)
  L1_1Magnet1N1_1_1 [N30UH_139.999983577095C, oriented by CS_L1_1Magnet1N1_1_1] = polyline(z=0mm, xy in mm: (58.5307, 3.6937) (63.2908, 7.3463) (53.5506, 20.0399) (48.7905, 16.3874) (58.5307, 3.6937), closed, covered)
  coordinate_system CS_L1_1Magnet2N1_1_1 = origin=(48.017903mm, 31.235601mm, (Magnet_Length / 2) + Magnet_Axial_Offset - 12.5mm) x=(0.95476142mm, 0.12569673mm, 0mm) y=(-0.12569673mm, 0.95476142mm, 0mm)
  L1_1Magnet2N1_1_1 [N30UH_139.999983577095C, oriented by CS_L1_1Magnet2N1_1_1] = polyline(z=0mm, xy in mm: (46.0877, 22.9124) (52.0364, 23.6956) (49.948, 39.5587) (43.9993, 38.7755) (46.0877, 22.9124), closed, covered)
  Rotor_Pocket_1_14 [vacuum] = polyline(z=0mm, xy in mm: (43.801, 38.7494) (45.8894, 22.8863) (45.9547, 22.3906) (49.2892, 20.8123) (52.1017, 23.1998) (52.0364, 23.6956) (46.0877, 22.9124) (43.9993, 38.7755) (49.948, 39.5587) (49.8827, 40.0544) (46.5482, 41.6327) (43.7358, 39.2451) (43.801, 38.7494), closed, covered, Arc from point 2 over 3, Arc from point 9 over 3)
  Shaft [vacuum] = polyline(z=0mm, xy in mm: (-40, 0) (-36.9551, -15.3073) (-28.2842, -28.2842) (-15.3073, -36.9551) (0, -40) (15.3073, -36.9551) (28.2842, -28.2842) (36.9551, -15.3073) (40, 0) (36.9551, 15.3073) (28.2842, 28.2842) (15.3073, 36.9551) (0, 40) (-15.3073, 36.9551) (-28.2842, 28.2842) (-36.9551, 15.3073) (-40, 0), closed, covered, Arc from point 0 over 3, Arc from point 2 over 3, Arc from point 4 over 3, Arc from point 6 over 3, Arc from point 8 over 3, Arc from point 10 over 3, Arc from point 12 over 3, Arc from point 14 over 3)
  Rotor_1.move(0mm, 0mm, 75mm)
  Rotor_1.sweep_along_vector((0mm, 0mm, -150mm))
  Shaft.move(0mm, 0mm, -75mm)
  Shaft.sweep_along_vector((0mm, 0mm, 150mm))
  Rotor_Pocket_1_8.move(0mm, 0mm, 75mm)
  Rotor_Pocket_1_8.sweep_along_vector((0mm, 0mm, -150mm))
  Rotor_Pocket_1_14.move(0mm, 0mm, 75mm)
  Rotor_Pocket_1_14.sweep_along_vector((0mm, 0mm, -150mm))
  Ph1_P2_C1 [Copper (Pure)_153.183177054828C] = user_primitive(RMxprt/LapCoil.dll, DiaGap=132mm, DiaYoke=DiaStatorYoke, Length=Stator_Lam_Length, Skew=StatorSkewAngle, Slots=SlotNumber_Stator, SlotType=SlotType_Stator, Hs0=Hs0_Stator, Hs1=Hs1_Stator, Hs2=17.541151mm, Bs0=Bs0_Stator, Bs1=4.3148444mm, Bs2=6.61426mm, Rs=Rs_Stator, FilletType=FilletType_Stator, Layers=Layers, CoilPitch=5, EndExt=WdgExt_F, SpanExt=SpanExt, BendAngle=0deg, SegAngle=SegAngle_Coil_Armature, LenRegion=Model_Length, InfoCoil=1)
  Ph1_P2_C1.rotate(axis=Z, angle=0deg)
  Ph2_P2_C1 [Copper (Pure)_153.183177054828C] = user_primitive(RMxprt/LapCoil.dll, DiaGap=132mm, DiaYoke=DiaStatorYoke, Length=Stator_Lam_Length, Skew=StatorSkewAngle, Slots=SlotNumber_Stator, SlotType=SlotType_Stator, Hs0=Hs0_Stator, Hs1=Hs1_Stator, Hs2=17.541151mm, Bs0=Bs0_Stator, Bs1=4.3148444mm, Bs2=6.61426mm, Rs=Rs_Stator, FilletType=FilletType_Stator, Layers=Layers, CoilPitch=5, EndExt=WdgExt_F, SpanExt=SpanExt, BendAngle=0deg, SegAngle=SegAngle_Coil_Armature, LenRegion=Model_Length, InfoCoil=1)
  Ph2_P2_C1.rotate(axis=Z, angle=15deg)
  Ph2_P2_C2 [Copper (Pure)_153.183177054828C] = user_primitive(RMxprt/LapCoil.dll, DiaGap=132mm, DiaYoke=DiaStatorYoke, Length=Stator_Lam_Length, Skew=StatorSkewAngle, Slots=SlotNumber_Stator, SlotType=SlotType_Stator, Hs0=Hs0_Stator, Hs1=Hs1_Stator, Hs2=17.541151mm, Bs0=Bs0_Stator, Bs1=4.3148444mm, Bs2=6.61426mm, Rs=Rs_Stator, FilletType=FilletType_Stator, Layers=Layers, CoilPitch=5, EndExt=WdgExt_F, SpanExt=SpanExt, BendAngle=0deg, SegAngle=SegAngle_Coil_Armature, LenRegion=Model_Length, InfoCoil=1)
  Ph2_P2_C2.rotate(axis=Z, angle=330deg)
  Ph3_P1_C1 [Copper (Pure)_153.183177054828C] = user_primitive(RMxprt/LapCoil.dll, DiaGap=132mm, DiaYoke=DiaStatorYoke, Length=Stator_Lam_Length, Skew=StatorSkewAngle, Slots=SlotNumber_Stator, SlotType=SlotType_Stator, Hs0=Hs0_Stator, Hs1=Hs1_Stator, Hs2=17.541151mm, Bs0=Bs0_Stator, Bs1=4.3148444mm, Bs2=6.61426mm, Rs=Rs_Stator, FilletType=FilletType_Stator, Layers=Layers, CoilPitch=5, EndExt=WdgExt_F, SpanExt=SpanExt, BendAngle=0deg, SegAngle=SegAngle_Coil_Armature, LenRegion=Model_Length, InfoCoil=1)
  Ph3_P1_C1.rotate(axis=Z, angle=30deg)
  Ph3_P1_C2 [Copper (Pure)_153.183177054828C] = user_primitive(RMxprt/LapCoil.dll, DiaGap=132mm, DiaYoke=DiaStatorYoke, Length=Stator_Lam_Length, Skew=StatorSkewAngle, Slots=SlotNumber_Stator, SlotType=SlotType_Stator, Hs0=Hs0_Stator, Hs1=Hs1_Stator, Hs2=17.541151mm, Bs0=Bs0_Stator, Bs1=4.3148444mm, Bs2=6.61426mm, Rs=Rs_Stator, FilletType=FilletType_Stator, Layers=Layers, CoilPitch=5, EndExt=WdgExt_F, SpanExt=SpanExt, BendAngle=0deg, SegAngle=SegAngle_Coil_Armature, LenRegion=Model_Length, InfoCoil=1)
  Ph3_P1_C2.rotate(axis=Z, angle=345deg)
  coordinate_system PhTerminal_CS = origin=(0mm, 0mm, Stator_Lam_Length/2) Euler Angle ZYZ phi=StatorSkewAngle/2 theta=0deg psi=0deg
  Ph1_P2_C1_Terminal [Copper (Pure)_153.183177054828C] = user_primitive(RMxprt/LapCoil.dll, DiaGap=132mm, DiaYoke=DiaStatorYoke, Length=Stator_Lam_Length, Skew=StatorSkewAngle, Slots=SlotNumber_Stator, SlotType=SlotType_Stator, Hs0=Hs0_Stator, Hs1=Hs1_Stator, Hs2=17.541151mm, Bs0=Bs0_Stator, Bs1=4.3148444mm, Bs2=6.61426mm, Rs=Rs_Stator, FilletType=FilletType_Stator, Layers=Layers, CoilPitch=5, EndExt=WdgExt_F, SpanExt=SpanExt, BendAngle=0deg, SegAngle=SegAngle_Coil_Armature, LenRegion=Model_Length, InfoCoil=2) in PhTerminal_CS
  Ph1_P2_C1_Terminal.rotate(axis=Z, angle=0deg) in PhTerminal_CS
  Ph2_P2_C1_Terminal [Copper (Pure)_153.183177054828C] = user_primitive(RMxprt/LapCoil.dll, DiaGap=132mm, DiaYoke=DiaStatorYoke, Length=Stator_Lam_Length, Skew=StatorSkewAngle, Slots=SlotNumber_Stator, SlotType=SlotType_Stator, Hs0=Hs0_Stator, Hs1=Hs1_Stator, Hs2=17.541151mm, Bs0=Bs0_Stator, Bs1=4.3148444mm, Bs2=6.61426mm, Rs=Rs_Stator, FilletType=FilletType_Stator, Layers=Layers, CoilPitch=5, EndExt=WdgExt_F, SpanExt=SpanExt, BendAngle=0deg, SegAngle=SegAngle_Coil_Armature, LenRegion=Model_Length, InfoCoil=2) in PhTerminal_CS
  Ph2_P2_C1_Terminal.rotate(axis=Z, angle=15deg) in PhTerminal_CS
  Ph3_P1_C1_Terminal [Copper (Pure)_153.183177054828C] = user_primitive(RMxprt/LapCoil.dll, DiaGap=132mm, DiaYoke=DiaStatorYoke, Length=Stator_Lam_Length, Skew=StatorSkewAngle, Slots=SlotNumber_Stator, SlotType=SlotType_Stator, Hs0=Hs0_Stator, Hs1=Hs1_Stator, Hs2=17.541151mm, Bs0=Bs0_Stator, Bs1=4.3148444mm, Bs2=6.61426mm, Rs=Rs_Stator, FilletType=FilletType_Stator, Layers=Layers, CoilPitch=5, EndExt=WdgExt_F, SpanExt=SpanExt, BendAngle=0deg, SegAngle=SegAngle_Coil_Armature, LenRegion=Model_Length, InfoCoil=2) in PhTerminal_CS
  Ph3_P1_C1_Terminal.rotate(axis=Z, angle=30deg) in PhTerminal_CS
  L1_1Magnet1N1_1_1.move(0mm, 0mm, Magnet_Length/2+Magnet_Axial_Offset) in PhTerminal_CS
  L1_1Magnet1N1_1_6 [N30UH_139.999983577095C, non-model, oriented by CS_L1_1Magnet1N1_1_6] = L1_1Magnet1N1_1_1.duplicate_along_line(step=(0mm, 0mm, -125mm), total=2) in PhTerminal_CS
  coordinate_system CS_L1_1Magnet1N1_1_6 = origin=(56.04069mm, 11.866879mm, (Magnet_Length / 2) + Magnet_Axial_Offset - 137.5mm) x=(0.76399928mm, 0.58623727mm, 0mm) y=(-0.58623727mm, 0.76399928mm, 0mm)
  L1_1Magnet1N1_1_6.sweep_along_vector((0mm, 0mm, -25mm)) in PhTerminal_CS
  L1_1Magnet1N1_1_5 [N30UH_139.999983577095C, non-model, oriented by CS_L1_1Magnet1N1_1_5] = L1_1Magnet1N1_1_1.duplicate_along_line(step=(0mm, 0mm, -100mm), total=2) in PhTerminal_CS
  coordinate_system CS_L1_1Magnet1N1_1_5 = origin=(56.04069mm, 11.866879mm, (Magnet_Length / 2) + Magnet_Axial_Offset - 112.5mm) x=(0.76399928mm, 0.58623727mm, 0mm) y=(-0.58623727mm, 0.76399928mm, 0mm)
  L1_1Magnet1N1_1_5.sweep_along_vector((0mm, 0mm, -25mm)) in PhTerminal_CS
  L1_1Magnet1N1_1_4 [N30UH_139.999983577095C, non-model, oriented by CS_L1_1Magnet1N1_1_4] = L1_1Magnet1N1_1_1.duplicate_along_line(step=(0mm, 0mm, -75mm), total=2) in PhTerminal_CS
  coordinate_system CS_L1_1Magnet1N1_1_4 = origin=(56.04069mm, 11.866879mm, (Magnet_Length / 2) + Magnet_Axial_Offset - 87.5mm) x=(0.76399928mm, 0.58623727mm, 0mm) y=(-0.58623727mm, 0.76399928mm, 0mm)
  L1_1Magnet1N1_1_4.sweep_along_vector((0mm, 0mm, -25mm)) in PhTerminal_CS
  L1_1Magnet1N1_1_3 [N30UH_139.999983577095C, oriented by CS_L1_1Magnet1N1_1_3] = L1_1Magnet1N1_1_1.duplicate_along_line(step=(0mm, 0mm, -50mm), total=2) in PhTerminal_CS
  coordinate_system CS_L1_1Magnet1N1_1_3 = origin=(56.04069mm, 11.866879mm, (Magnet_Length / 2) + Magnet_Axial_Offset - 62.5mm) x=(0.76399928mm, 0.58623727mm, 0mm) y=(-0.58623727mm, 0.76399928mm, 0mm)
  L1_1Magnet1N1_1_3.sweep_along_vector((0mm, 0mm, -25mm)) in PhTerminal_CS
  L1_1Magnet1N1_1_2 [N30UH_139.999983577095C, oriented by CS_L1_1Magnet1N1_1_2] = L1_1Magnet1N1_1_1.duplicate_along_line(step=(0mm, 0mm, -25mm), total=2) in PhTerminal_CS
  coordinate_system CS_L1_1Magnet1N1_1_2 = origin=(56.04069mm, 11.866879mm, (Magnet_Length / 2) + Magnet_Axial_Offset - 37.5mm) x=(0.76399928mm, 0.58623727mm, 0mm) y=(-0.58623727mm, 0.76399928mm, 0mm)
  [L1_1Magnet1N1_1_2, L1_1Magnet1N1_1_1].sweep_along_vector((0mm, 0mm, -25mm)) in PhTerminal_CS
  L1_1Magnet2N1_1_1.move(0mm, 0mm, Magnet_Length/2+Magnet_Axial_Offset) in PhTerminal_CS
  L1_1Magnet2N1_1_6 [N30UH_139.999983577095C, non-model, oriented by CS_L1_1Magnet2N1_1_6] = L1_1Magnet2N1_1_1.duplicate_along_line(step=(0mm, 0mm, -125mm), total=2) in PhTerminal_CS
  coordinate_system CS_L1_1Magnet2N1_1_6 = origin=(48.017903mm, 31.235601mm, (Magnet_Length / 2) + Magnet_Axial_Offset - 137.5mm) x=(0.95476142mm, 0.12569673mm, 0mm) y=(-0.12569673mm, 0.95476142mm, 0mm)
  L1_1Magnet2N1_1_6.sweep_along_vector((0mm, 0mm, -25mm)) in PhTerminal_CS
  L1_1Magnet2N1_1_5 [N30UH_139.999983577095C, non-model, oriented by CS_L1_1Magnet2N1_1_5] = L1_1Magnet2N1_1_1.duplicate_along_line(step=(0mm, 0mm, -100mm), total=2) in PhTerminal_CS
  coordinate_system CS_L1_1Magnet2N1_1_5 = origin=(48.017903mm, 31.235601mm, (Magnet_Length / 2) + Magnet_Axial_Offset - 112.5mm) x=(0.95476142mm, 0.12569673mm, 0mm) y=(-0.12569673mm, 0.95476142mm, 0mm)
  L1_1Magnet2N1_1_5.sweep_along_vector((0mm, 0mm, -25mm)) in PhTerminal_CS
  L1_1Magnet2N1_1_4 [N30UH_139.999983577095C, non-model, oriented by CS_L1_1Magnet2N1_1_4] = L1_1Magnet2N1_1_1.duplicate_along_line(step=(0mm, 0mm, -75mm), total=2) in PhTerminal_CS
  coordinate_system CS_L1_1Magnet2N1_1_4 = origin=(48.017903mm, 31.235601mm, (Magnet_Length / 2) + Magnet_Axial_Offset - 87.5mm) x=(0.95476142mm, 0.12569673mm, 0mm) y=(-0.12569673mm, 0.95476142mm, 0mm)
  L1_1Magnet2N1_1_4.sweep_along_vector((0mm, 0mm, -25mm)) in PhTerminal_CS
  L1_1Magnet2N1_1_3 [N30UH_139.999983577095C, oriented by CS_L1_1Magnet2N1_1_3] = L1_1Magnet2N1_1_1.duplicate_along_line(step=(0mm, 0mm, -50mm), total=2) in PhTerminal_CS
  coordinate_system CS_L1_1Magnet2N1_1_3 = origin=(48.017903mm, 31.235601mm, (Magnet_Length / 2) + Magnet_Axial_Offset - 62.5mm) x=(0.95476142mm, 0.12569673mm, 0mm) y=(-0.12569673mm, 0.95476142mm, 0mm)
  L1_1Magnet2N1_1_3.sweep_along_vector((0mm, 0mm, -25mm)) in PhTerminal_CS
  L1_1Magnet2N1_1_2 [N30UH_139.999983577095C, oriented by CS_L1_1Magnet2N1_1_2] = L1_1Magnet2N1_1_1.duplicate_along_line(step=(0mm, 0mm, -25mm), total=2) in PhTerminal_CS
  coordinate_system CS_L1_1Magnet2N1_1_2 = origin=(48.017903mm, 31.235601mm, (Magnet_Length / 2) + Magnet_Axial_Offset - 37.5mm) x=(0.95476142mm, 0.12569673mm, 0mm) y=(-0.12569673mm, 0.95476142mm, 0mm)
  [L1_1Magnet2N1_1_2, L1_1Magnet2N1_1_1].sweep_along_vector((0mm, 0mm, -25mm)) in PhTerminal_CS
  coordinate_system CS_L1_1Magnet2S3_1_1 = origin=(-56.04069mm, 11.866879mm, (Magnet_Length / 2) + Magnet_Axial_Offset - 12.5mm) x=(0.76399928mm, -0.58623727mm, 0mm) y=(0.58623727mm, 0.76399928mm, 0mm)
  coordinate_system CS_L1_1Magnet1N3_1_1 = origin=(-56.04069mm, -11.866879mm, (Magnet_Length / 2) + Magnet_Axial_Offset - 12.5mm) x=(-0.76399928mm, -0.58623727mm, 0mm) y=(0.58623727mm, -0.76399928mm, 0mm)
  coordinate_system CS_L1_1Magnet1S3_1_1 = origin=(-48.017903mm, 31.235601mm, (Magnet_Length / 2) + Magnet_Axial_Offset - 12.5mm) x=(0.95476142mm, -0.12569673mm, 0mm) y=(0.12569673mm, 0.95476142mm, 0mm)
  coordinate_system CS_L1_1Magnet1S4_1_1 = origin=(-31.235601mm, -48.017903mm, (Magnet_Length / 2) + Magnet_Axial_Offset - 12.5mm) x=(0.12569673mm, 0.95476142mm, 0mm) y=(-0.95476142mm, 0.12569673mm, 0mm)
  coordinate_system CS_L1_1Magnet1N2_1_1 = origin=(-11.866879mm, 56.04069mm, (Magnet_Length / 2) + Magnet_Axial_Offset - 12.5mm) x=(-0.58623727mm, 0.76399928mm, 0mm) y=(-0.76399928mm, -0.58623727mm, 0mm)
  coordinate_system CS_L1_1Magnet1N4_1_1 = origin=(11.866879mm, -56.04069mm, (Magnet_Length / 2) + Magnet_Axial_Offset - 12.5mm) x=(0.58623727mm, -0.76399928mm, 0mm) y=(0.76399928mm, 0.58623727mm, 0mm)
  coordinate_system CS_L1_1Magnet1S2_1_1 = origin=(31.235601mm, 48.017903mm, (Magnet_Length / 2) + Magnet_Axial_Offset - 12.5mm) x=(-0.12569673mm, -0.95476142mm, 0mm) y=(0.95476142mm, -0.12569673mm, 0mm)
  coordinate_system CS_L1_1Magnet1S1_1_1 = origin=(48.017903mm, -31.235601mm, (Magnet_Length / 2) + Magnet_Axial_Offset - 12.5mm) x=(-0.95476142mm, 0.12569673mm, 0mm) y=(-0.12569673mm, -0.95476142mm, 0mm)
  coordinate_system CS_L1_1Magnet2N3_1_1 = origin=(-48.017903mm, -31.235601mm, (Magnet_Length / 2) + Magnet_Axial_Offset - 12.5mm) x=(-0.95476142mm, -0.12569673mm, 0mm) y=(0.12569673mm, -0.95476142mm, 0mm)
  coordinate_system CS_L1_1Magnet2N2_1_1 = origin=(-31.235601mm, 48.017903mm, (Magnet_Length / 2) + Magnet_Axial_Offset - 12.5mm) x=(-0.12569673mm, 0.95476142mm, 0mm) y=(-0.95476142mm, -0.12569673mm, 0mm)
  coordinate_system CS_L1_1Magnet2S4_1_1 = origin=(-11.866879mm, -56.04069mm, (Magnet_Length / 2) + Magnet_Axial_Offset - 12.5mm) x=(0.58623727mm, 0.76399928mm, 0mm) y=(-0.76399928mm, 0.58623727mm, 0mm)
  coordinate_system CS_L1_1Magnet2S2_1_1 = origin=(11.866879mm, 56.04069mm, (Magnet_Length / 2) + Magnet_Axial_Offset - 12.5mm) x=(-0.58623727mm, -0.76399928mm, 0mm) y=(0.76399928mm, -0.58623727mm, 0mm)
  coordinate_system CS_L1_1Magnet2N4_1_1 = origin=(31.235601mm, -48.017903mm, (Magnet_Length / 2) + Magnet_Axial_Offset - 12.5mm) x=(0.12569673mm, -0.95476142mm, 0mm) y=(0.95476142mm, 0.12569673mm, 0mm)
  coordinate_system CS_L1_1Magnet2S1_1_1 = origin=(56.04069mm, -11.866879mm, (Magnet_Length / 2) + Magnet_Axial_Offset - 12.5mm) x=(-0.76399928mm, 0.58623727mm, 0mm) y=(-0.58623727mm, -0.76399928mm, 0mm)
  coordinate_system CS_L1_1Magnet2S3_1_2 = origin=(-56.04069mm, 11.866879mm, (Magnet_Length / 2) + Magnet_Axial_Offset - 37.5mm) x=(0.76399928mm, -0.58623727mm, 0mm) y=(0.58623727mm, 0.76399928mm, 0mm)
  coordinate_system CS_L1_1Magnet1N3_1_2 = origin=(-56.04069mm, -11.866879mm, (Magnet_Length / 2) + Magnet_Axial_Offset - 37.5mm) x=(-0.76399928mm, -0.58623727mm, 0mm) y=(0.58623727mm, -0.76399928mm, 0mm)
  coordinate_system CS_L1_1Magnet1S3_1_2 = origin=(-48.017903mm, 31.235601mm, (Magnet_Length / 2) + Magnet_Axial_Offset - 37.5mm) x=(0.95476142mm, -0.12569673mm, 0mm) y=(0.12569673mm, 0.95476142mm, 0mm)
  coordinate_system CS_L1_1Magnet1S4_1_2 = origin=(-31.235601mm, -48.017903mm, (Magnet_Length / 2) + Magnet_Axial_Offset - 37.5mm) x=(0.12569673mm, 0.95476142mm, 0mm) y=(-0.95476142mm, 0.12569673mm, 0mm)
  coordinate_system CS_L1_1Magnet1N2_1_2 = origin=(-11.866879mm, 56.04069mm, (Magnet_Length / 2) + Magnet_Axial_Offset - 37.5mm) x=(-0.58623727mm, 0.76399928mm, 0mm) y=(-0.76399928mm, -0.58623727mm, 0mm)
  coordinate_system CS_L1_1Magnet1N4_1_2 = origin=(11.866879mm, -56.04069mm, (Magnet_Length / 2) + Magnet_Axial_Offset - 37.5mm) x=(0.58623727mm, -0.76399928mm, 0mm) y=(0.76399928mm, 0.58623727mm, 0mm)
  coordinate_system CS_L1_1Magnet1S2_1_2 = origin=(31.235601mm, 48.017903mm, (Magnet_Length / 2) + Magnet_Axial_Offset - 37.5mm) x=(-0.12569673mm, -0.95476142mm, 0mm) y=(0.95476142mm, -0.12569673mm, 0mm)
  coordinate_system CS_L1_1Magnet1S1_1_2 = origin=(48.017903mm, -31.235601mm, (Magnet_Length / 2) + Magnet_Axial_Offset - 37.5mm) x=(-0.95476142mm, 0.12569673mm, 0mm) y=(-0.12569673mm, -0.95476142mm, 0mm)
  coordinate_system CS_L1_1Magnet2N3_1_2 = origin=(-48.017903mm, -31.235601mm, (Magnet_Length / 2) + Magnet_Axial_Offset - 37.5mm) x=(-0.95476142mm, -0.12569673mm, 0mm) y=(0.12569673mm, -0.95476142mm, 0mm)
  coordinate_system CS_L1_1Magnet2N2_1_2 = origin=(-31.235601mm, 48.017903mm, (Magnet_Length / 2) + Magnet_Axial_Offset - 37.5mm) x=(-0.12569673mm, 0.95476142mm, 0mm) y=(-0.95476142mm, -0.12569673mm, 0mm)
  coordinate_system CS_L1_1Magnet2S4_1_2 = origin=(-11.866879mm, -56.04069mm, (Magnet_Length / 2) + Magnet_Axial_Offset - 37.5mm) x=(0.58623727mm, 0.76399928mm, 0mm) y=(-0.76399928mm, 0.58623727mm, 0mm)
  coordinate_system CS_L1_1Magnet2S2_1_2 = origin=(11.866879mm, 56.04069mm, (Magnet_Length / 2) + Magnet_Axial_Offset - 37.5mm) x=(-0.58623727mm, -0.76399928mm, 0mm) y=(0.76399928mm, -0.58623727mm, 0mm)
  coordinate_system CS_L1_1Magnet2N4_1_2 = origin=(31.235601mm, -48.017903mm, (Magnet_Length / 2) + Magnet_Axial_Offset - 37.5mm) x=(0.12569673mm, -0.95476142mm, 0mm) y=(0.95476142mm, 0.12569673mm, 0mm)
  coordinate_system CS_L1_1Magnet2S1_1_2 = origin=(56.04069mm, -11.866879mm, (Magnet_Length / 2) + Magnet_Axial_Offset - 37.5mm) x=(-0.76399928mm, 0.58623727mm, 0mm) y=(-0.58623727mm, -0.76399928mm, 0mm)
  coordinate_system CS_L1_1Magnet2S3_1_3 = origin=(-56.04069mm, 11.866879mm, (Magnet_Length / 2) + Magnet_Axial_Offset - 62.5mm) x=(0.76399928mm, -0.58623727mm, 0mm) y=(0.58623727mm, 0.76399928mm, 0mm)
  coordinate_system CS_L1_1Magnet1N3_1_3 = origin=(-56.04069mm, -11.866879mm, (Magnet_Length / 2) + Magnet_Axial_Offset - 62.5mm) x=(-0.76399928mm, -0.58623727mm, 0mm) y=(0.58623727mm, -0.76399928mm, 0mm)
  coordinate_system CS_L1_1Magnet1S3_1_3 = origin=(-48.017903mm, 31.235601mm, (Magnet_Length / 2) + Magnet_Axial_Offset - 62.5mm) x=(0.95476142mm, -0.12569673mm, 0mm) y=(0.12569673mm, 0.95476142mm, 0mm)
  coordinate_system CS_L1_1Magnet1S4_1_3 = origin=(-31.235601mm, -48.017903mm, (Magnet_Length / 2) + Magnet_Axial_Offset - 62.5mm) x=(0.12569673mm, 0.95476142mm, 0mm) y=(-0.95476142mm, 0.12569673mm, 0mm)
  coordinate_system CS_L1_1Magnet1N2_1_3 = origin=(-11.866879mm, 56.04069mm, (Magnet_Length / 2) + Magnet_Axial_Offset - 62.5mm) x=(-0.58623727mm, 0.76399928mm, 0mm) y=(-0.76399928mm, -0.58623727mm, 0mm)
  coordinate_system CS_L1_1Magnet1N4_1_3 = origin=(11.866879mm, -56.04069mm, (Magnet_Length / 2) + Magnet_Axial_Offset - 62.5mm) x=(0.58623727mm, -0.76399928mm, 0mm) y=(0.76399928mm, 0.58623727mm, 0mm)
  coordinate_system CS_L1_1Magnet1S2_1_3 = origin=(31.235601mm, 48.017903mm, (Magnet_Length / 2) + Magnet_Axial_Offset - 62.5mm) x=(-0.12569673mm, -0.95476142mm, 0mm) y=(0.95476142mm, -0.12569673mm, 0mm)
  coordinate_system CS_L1_1Magnet1S1_1_3 = origin=(48.017903mm, -31.235601mm, (Magnet_Length / 2) + Magnet_Axial_Offset - 62.5mm) x=(-0.95476142mm, 0.12569673mm, 0mm) y=(-0.12569673mm, -0.95476142mm, 0mm)
  coordinate_system CS_L1_1Magnet2N3_1_3 = origin=(-48.017903mm, -31.235601mm, (Magnet_Length / 2) + Magnet_Axial_Offset - 62.5mm) x=(-0.95476142mm, -0.12569673mm, 0mm) y=(0.12569673mm, -0.95476142mm, 0mm)
  coordinate_system CS_L1_1Magnet2N2_1_3 = origin=(-31.235601mm, 48.017903mm, (Magnet_Length / 2) + Magnet_Axial_Offset - 62.5mm) x=(-0.12569673mm, 0.95476142mm, 0mm) y=(-0.95476142mm, -0.12569673mm, 0mm)
  coordinate_system CS_L1_1Magnet2S4_1_3 = origin=(-11.866879mm, -56.04069mm, (Magnet_Length / 2) + Magnet_Axial_Offset - 62.5mm) x=(0.58623727mm, 0.76399928mm, 0mm) y=(-0.76399928mm, 0.58623727mm, 0mm)
  coordinate_system CS_L1_1Magnet2S2_1_3 = origin=(11.866879mm, 56.04069mm, (Magnet_Length / 2) + Magnet_Axial_Offset - 62.5mm) x=(-0.58623727mm, -0.76399928mm, 0mm) y=(0.76399928mm, -0.58623727mm, 0mm)
  coordinate_system CS_L1_1Magnet2N4_1_3 = origin=(31.235601mm, -48.017903mm, (Magnet_Length / 2) + Magnet_Axial_Offset - 62.5mm) x=(0.12569673mm, -0.95476142mm, 0mm) y=(0.95476142mm, 0.12569673mm, 0mm)
  coordinate_system CS_L1_1Magnet2S1_1_3 = origin=(56.04069mm, -11.866879mm, (Magnet_Length / 2) + Magnet_Axial_Offset - 62.5mm) x=(-0.76399928mm, 0.58623727mm, 0mm) y=(-0.58623727mm, -0.76399928mm, 0mm)
  coordinate_system CS_L1_1Magnet2S3_1_4 = origin=(-56.04069mm, 11.866879mm, (Magnet_Length / 2) + Magnet_Axial_Offset - 87.5mm) x=(0.76399928mm, -0.58623727mm, 0mm) y=(0.58623727mm, 0.76399928mm, 0mm)
  coordinate_system CS_L1_1Magnet1N3_1_4 = origin=(-56.04069mm, -11.866879mm, (Magnet_Length / 2) + Magnet_Axial_Offset - 87.5mm) x=(-0.76399928mm, -0.58623727mm, 0mm) y=(0.58623727mm, -0.76399928mm, 0mm)
  coordinate_system CS_L1_1Magnet1S3_1_4 = origin=(-48.017903mm, 31.235601mm, (Magnet_Length / 2) + Magnet_Axial_Offset - 87.5mm) x=(0.95476142mm, -0.12569673mm, 0mm) y=(0.12569673mm, 0.95476142mm, 0mm)
  coordinate_system CS_L1_1Magnet1S4_1_4 = origin=(-31.235601mm, -48.017903mm, (Magnet_Length / 2) + Magnet_Axial_Offset - 87.5mm) x=(0.12569673mm, 0.95476142mm, 0mm) y=(-0.95476142mm, 0.12569673mm, 0mm)
  coordinate_system CS_L1_1Magnet1N2_1_4 = origin=(-11.866879mm, 56.04069mm, (Magnet_Length / 2) + Magnet_Axial_Offset - 87.5mm) x=(-0.58623727mm, 0.76399928mm, 0mm) y=(-0.76399928mm, -0.58623727mm, 0mm)
  coordinate_system CS_L1_1Magnet1N4_1_4 = origin=(11.866879mm, -56.04069mm, (Magnet_Length / 2) + Magnet_Axial_Offset - 87.5mm) x=(0.58623727mm, -0.76399928mm, 0mm) y=(0.76399928mm, 0.58623727mm, 0mm)
  coordinate_system CS_L1_1Magnet1S2_1_4 = origin=(31.235601mm, 48.017903mm, (Magnet_Length / 2) + Magnet_Axial_Offset - 87.5mm) x=(-0.12569673mm, -0.95476142mm, 0mm) y=(0.95476142mm, -0.12569673mm, 0mm)
  coordinate_system CS_L1_1Magnet1S1_1_4 = origin=(48.017903mm, -31.235601mm, (Magnet_Length / 2) + Magnet_Axial_Offset - 87.5mm) x=(-0.95476142mm, 0.12569673mm, 0mm) y=(-0.12569673mm, -0.95476142mm, 0mm)
  coordinate_system CS_L1_1Magnet2N3_1_4 = origin=(-48.017903mm, -31.235601mm, (Magnet_Length / 2) + Magnet_Axial_Offset - 87.5mm) x=(-0.95476142mm, -0.12569673mm, 0mm) y=(0.12569673mm, -0.95476142mm, 0mm)
  coordinate_system CS_L1_1Magnet2N2_1_4 = origin=(-31.235601mm, 48.017903mm, (Magnet_Length / 2) + Magnet_Axial_Offset - 87.5mm) x=(-0.12569673mm, 0.95476142mm, 0mm) y=(-0.95476142mm, -0.12569673mm, 0mm)
  coordinate_system CS_L1_1Magnet2S4_1_4 = origin=(-11.866879mm, -56.04069mm, (Magnet_Length / 2) + Magnet_Axial_Offset - 87.5mm) x=(0.58623727mm, 0.76399928mm, 0mm) y=(-0.76399928mm, 0.58623727mm, 0mm)
  coordinate_system CS_L1_1Magnet2S2_1_4 = origin=(11.866879mm, 56.04069mm, (Magnet_Length / 2) + Magnet_Axial_Offset - 87.5mm) x=(-0.58623727mm, -0.76399928mm, 0mm) y=(0.76399928mm, -0.58623727mm, 0mm)
  coordinate_system CS_L1_1Magnet2N4_1_4 = origin=(31.235601mm, -48.017903mm, (Magnet_Length / 2) + Magnet_Axial_Offset - 87.5mm) x=(0.12569673mm, -0.95476142mm, 0mm) y=(0.95476142mm, 0.12569673mm, 0mm)
  coordinate_system CS_L1_1Magnet2S1_1_4 = origin=(56.04069mm, -11.866879mm, (Magnet_Length / 2) + Magnet_Axial_Offset - 87.5mm) x=(-0.76399928mm, 0.58623727mm, 0mm) y=(-0.58623727mm, -0.76399928mm, 0mm)
  coordinate_system CS_L1_1Magnet2S3_1_5 = origin=(-56.04069mm, 11.866879mm, (Magnet_Length / 2) + Magnet_Axial_Offset - 112.5mm) x=(0.76399928mm, -0.58623727mm, 0mm) y=(0.58623727mm, 0.76399928mm, 0mm)
  coordinate_system CS_L1_1Magnet1N3_1_5 = origin=(-56.04069mm, -11.866879mm, (Magnet_Length / 2) + Magnet_Axial_Offset - 112.5mm) x=(-0.76399928mm, -0.58623727mm, 0mm) y=(0.58623727mm, -0.76399928mm, 0mm)
  coordinate_system CS_L1_1Magnet1S3_1_5 = origin=(-48.017903mm, 31.235601mm, (Magnet_Length / 2) + Magnet_Axial_Offset - 112.5mm) x=(0.95476142mm, -0.12569673mm, 0mm) y=(0.12569673mm, 0.95476142mm, 0mm)
  coordinate_system CS_L1_1Magnet1S4_1_5 = origin=(-31.235601mm, -48.017903mm, (Magnet_Length / 2) + Magnet_Axial_Offset - 112.5mm) x=(0.12569673mm, 0.95476142mm, 0mm) y=(-0.95476142mm, 0.12569673mm, 0mm)
  coordinate_system CS_L1_1Magnet1N2_1_5 = origin=(-11.866879mm, 56.04069mm, (Magnet_Length / 2) + Magnet_Axial_Offset - 112.5mm) x=(-0.58623727mm, 0.76399928mm, 0mm) y=(-0.76399928mm, -0.58623727mm, 0mm)
  coordinate_system CS_L1_1Magnet1N4_1_5 = origin=(11.866879mm, -56.04069mm, (Magnet_Length / 2) + Magnet_Axial_Offset - 112.5mm) x=(0.58623727mm, -0.76399928mm, 0mm) y=(0.76399928mm, 0.58623727mm, 0mm)
  coordinate_system CS_L1_1Magnet1S2_1_5 = origin=(31.235601mm, 48.017903mm, (Magnet_Length / 2) + Magnet_Axial_Offset - 112.5mm) x=(-0.12569673mm, -0.95476142mm, 0mm) y=(0.95476142mm, -0.12569673mm, 0mm)
  coordinate_system CS_L1_1Magnet1S1_1_5 = origin=(48.017903mm, -31.235601mm, (Magnet_Length / 2) + Magnet_Axial_Offset - 112.5mm) x=(-0.95476142mm, 0.12569673mm, 0mm) y=(-0.12569673mm, -0.95476142mm, 0mm)
  coordinate_system CS_L1_1Magnet2N3_1_5 = origin=(-48.017903mm, -31.235601mm, (Magnet_Length / 2) + Magnet_Axial_Offset - 112.5mm) x=(-0.95476142mm, -0.12569673mm, 0mm) y=(0.12569673mm, -0.95476142mm, 0mm)
  coordinate_system CS_L1_1Magnet2N2_1_5 = origin=(-31.235601mm, 48.017903mm, (Magnet_Length / 2) + Magnet_Axial_Offset - 112.5mm) x=(-0.12569673mm, 0.95476142mm, 0mm) y=(-0.95476142mm, -0.12569673mm, 0mm)
  coordinate_system CS_L1_1Magnet2S4_1_5 = origin=(-11.866879mm, -56.04069mm, (Magnet_Length / 2) + Magnet_Axial_Offset - 112.5mm) x=(0.58623727mm, 0.76399928mm, 0mm) y=(-0.76399928mm, 0.58623727mm, 0mm)
  coordinate_system CS_L1_1Magnet2S2_1_5 = origin=(11.866879mm, 56.04069mm, (Magnet_Length / 2) + Magnet_Axial_Offset - 112.5mm) x=(-0.58623727mm, -0.76399928mm, 0mm) y=(0.76399928mm, -0.58623727mm, 0mm)
  coordinate_system CS_L1_1Magnet2N4_1_5 = origin=(31.235601mm, -48.017903mm, (Magnet_Length / 2) + Magnet_Axial_Offset - 112.5mm) x=(0.12569673mm, -0.95476142mm, 0mm) y=(0.95476142mm, 0.12569673mm, 0mm)
  coordinate_system CS_L1_1Magnet2S1_1_5 = origin=(56.04069mm, -11.866879mm, (Magnet_Length / 2) + Magnet_Axial_Offset - 112.5mm) x=(-0.76399928mm, 0.58623727mm, 0mm) y=(-0.58623727mm, -0.76399928mm, 0mm)
  coordinate_system CS_L1_1Magnet2S3_1_6 = origin=(-56.04069mm, 11.866879mm, (Magnet_Length / 2) + Magnet_Axial_Offset - 137.5mm) x=(0.76399928mm, -0.58623727mm, 0mm) y=(0.58623727mm, 0.76399928mm, 0mm)
  coordinate_system CS_L1_1Magnet1N3_1_6 = origin=(-56.04069mm, -11.866879mm, (Magnet_Length / 2) + Magnet_Axial_Offset - 137.5mm) x=(-0.76399928mm, -0.58623727mm, 0mm) y=(0.58623727mm, -0.76399928mm, 0mm)
  coordinate_system CS_L1_1Magnet1S3_1_6 = origin=(-48.017903mm, 31.235601mm, (Magnet_Length / 2) + Magnet_Axial_Offset - 137.5mm) x=(0.95476142mm, -0.12569673mm, 0mm) y=(0.12569673mm, 0.95476142mm, 0mm)
  coordinate_system CS_L1_1Magnet1S4_1_6 = origin=(-31.235601mm, -48.017903mm, (Magnet_Length / 2) + Magnet_Axial_Offset - 137.5mm) x=(0.12569673mm, 0.95476142mm, 0mm) y=(-0.95476142mm, 0.12569673mm, 0mm)
  coordinate_system CS_L1_1Magnet1N2_1_6 = origin=(-11.866879mm, 56.04069mm, (Magnet_Length / 2) + Magnet_Axial_Offset - 137.5mm) x=(-0.58623727mm, 0.76399928mm, 0mm) y=(-0.76399928mm, -0.58623727mm, 0mm)
  coordinate_system CS_L1_1Magnet1N4_1_6 = origin=(11.866879mm, -56.04069mm, (Magnet_Length / 2) + Magnet_Axial_Offset - 137.5mm) x=(0.58623727mm, -0.76399928mm, 0mm) y=(0.76399928mm, 0.58623727mm, 0mm)
  coordinate_system CS_L1_1Magnet1S2_1_6 = origin=(31.235601mm, 48.017903mm, (Magnet_Length / 2) + Magnet_Axial_Offset - 137.5mm) x=(-0.12569673mm, -0.95476142mm, 0mm) y=(0.95476142mm, -0.12569673mm, 0mm)
  coordinate_system CS_L1_1Magnet1S1_1_6 = origin=(48.017903mm, -31.235601mm, (Magnet_Length / 2) + Magnet_Axial_Offset - 137.5mm) x=(-0.95476142mm, 0.12569673mm, 0mm) y=(-0.12569673mm, -0.95476142mm, 0mm)
  coordinate_system CS_L1_1Magnet2N3_1_6 = origin=(-48.017903mm, -31.235601mm, (Magnet_Length / 2) + Magnet_Axial_Offset - 137.5mm) x=(-0.95476142mm, -0.12569673mm, 0mm) y=(0.12569673mm, -0.95476142mm, 0mm)
  coordinate_system CS_L1_1Magnet2N2_1_6 = origin=(-31.235601mm, 48.017903mm, (Magnet_Length / 2) + Magnet_Axial_Offset - 137.5mm) x=(-0.12569673mm, 0.95476142mm, 0mm) y=(-0.95476142mm, -0.12569673mm, 0mm)
  coordinate_system CS_L1_1Magnet2S4_1_6 = origin=(-11.866879mm, -56.04069mm, (Magnet_Length / 2) + Magnet_Axial_Offset - 137.5mm) x=(0.58623727mm, 0.76399928mm, 0mm) y=(-0.76399928mm, 0.58623727mm, 0mm)
  coordinate_system CS_L1_1Magnet2S2_1_6 = origin=(11.866879mm, 56.04069mm, (Magnet_Length / 2) + Magnet_Axial_Offset - 137.5mm) x=(-0.58623727mm, -0.76399928mm, 0mm) y=(0.76399928mm, -0.58623727mm, 0mm)
  coordinate_system CS_L1_1Magnet2N4_1_6 = origin=(31.235601mm, -48.017903mm, (Magnet_Length / 2) + Magnet_Axial_Offset - 137.5mm) x=(0.12569673mm, -0.95476142mm, 0mm) y=(0.95476142mm, 0.12569673mm, 0mm)
  coordinate_system CS_L1_1Magnet2S1_1_6 = origin=(56.04069mm, -11.866879mm, (Magnet_Length / 2) + Magnet_Axial_Offset - 137.5mm) x=(-0.76399928mm, 0.58623727mm, 0mm) y=(-0.58623727mm, -0.76399928mm, 0mm)
  Rotating_Band [vacuum] = user_primitive(RMxprt/Band.dll, DiaGap=DiaGap - (2 * (Airgap - Banding_Thickness)) + (4 * ((airgap - Banding_Thickness - Sleeve_Thickness) / 4)), DiaYoke=Shaft_Hole_Diameter, Length=242.23097mm, SegAngle=0deg, Fractions=SymmetryFactor, HalfAxial=HalfAxial, InfoCore=0)
  Band_Tool = user_primitive(RMxprt/Band.dll, DiaGap=1mm, DiaYoke=DiaOuter, Length=242.23097mm, SegAngle=SegAngle, Fractions=SymmetryFactor, HalfAxial=HalfAxial, InfoCore=1)
  Whole_Region [vacuum] = user_primitive(RMxprt/Band.dll, DiaGap=DiaGap+Airgap, DiaYoke=DiaOuter, Length=242.23097mm, SegAngle=SegAngle, Fractions=SymmetryFactor, HalfAxial=HalfAxial, InfoCore=100)
  Band_Tool_1 = Band_Tool.copy()
  Stator_Lamination_Primitive.subtract(Band_Tool_1)
  Band_Tool_2 = Band_Tool.copy()
  Rotor_1.subtract(Band_Tool_2)
  Band_Tool_13 = Band_Tool.copy()
  Rotor_Pocket_1_8.subtract(Band_Tool_13)
  Band_Tool_20 = Band_Tool.copy()
  L1_1Magnet1N1_1_1.subtract(Band_Tool_20)
  Band_Tool_26 = Band_Tool.copy()
  L1_1Magnet2N1_1_1.subtract(Band_Tool_26)
  Band_Tool_33 = Band_Tool.copy()
  Rotor_Pocket_1_14.subtract(Band_Tool_33)
  Band_Tool_35 = Band_Tool.copy()
  Shaft.subtract(Band_Tool_35)
  Band_Tool_36 = Band_Tool.copy()
  Ph1_P2_C1.subtract(Band_Tool_36)
  Band_Tool_37 = Band_Tool.copy()
  Ph2_P2_C1.subtract(Band_Tool_37)
  Band_Tool_38 = Band_Tool.copy()
  Ph2_P2_C2.subtract(Band_Tool_38)
  Band_Tool_39 = Band_Tool.copy()
  Ph3_P1_C1.subtract(Band_Tool_39)
  Band_Tool_40 = Band_Tool.copy()
  Ph3_P1_C2.subtract(Band_Tool_40)
  Band_Tool_41 = Band_Tool.copy()
  Ph1_P2_C1_Terminal.subtract(Band_Tool_41)
  Band_Tool_42 = Band_Tool.copy()
  Ph2_P2_C1_Terminal.subtract(Band_Tool_42)
  Band_Tool_43 = Band_Tool.copy()
  Ph3_P1_C1_Terminal.subtract(Band_Tool_43)
  Band_Tool_84 = Band_Tool.copy()
  L1_1Magnet1N1_1_6.subtract(Band_Tool_84)
  Band_Tool_85 = Band_Tool.copy()
  L1_1Magnet1N1_1_5.subtract(Band_Tool_85)
  Band_Tool_86 = Band_Tool.copy()
  L1_1Magnet1N1_1_4.subtract(Band_Tool_86)
  Band_Tool_87 = Band_Tool.copy()
  L1_1Magnet1N1_1_3.subtract(Band_Tool_87)
  Band_Tool_88 = Band_Tool.copy()
  L1_1Magnet1N1_1_2.subtract(Band_Tool_88)
  Band_Tool_114 = Band_Tool.copy()
  L1_1Magnet2N1_1_6.subtract(Band_Tool_114)
  Band_Tool_115 = Band_Tool.copy()
  L1_1Magnet2N1_1_5.subtract(Band_Tool_115)
  Band_Tool_116 = Band_Tool.copy()
  L1_1Magnet2N1_1_4.subtract(Band_Tool_116)
  Band_Tool_117 = Band_Tool.copy()
  L1_1Magnet2N1_1_3.subtract(Band_Tool_117)
  Band_Tool_118 = Band_Tool.copy()
  L1_1Magnet2N1_1_2.subtract(Band_Tool_118)
  Band_Tool_124 = Band_Tool.copy()
  Rotating_Band.subtract(Band_Tool_124)
  Whole_Region.subtract(Band_Tool)
  Boundary_Independent [vacuum] = user_primitive(RMxprt/Band.dll, DiaGap=DiaGap+Airgap, DiaYoke=DiaOuter, Length=242.23097mm, SegAngle=SegAngle, Fractions=SymmetryFactor, HalfAxial=HalfAxial, InfoCore=2)
  Boundary_Dependent [vacuum] = user_primitive(RMxprt/Band.dll, DiaGap=DiaGap+Airgap, DiaYoke=DiaOuter, Length=242.23097mm, SegAngle=SegAngle, Fractions=SymmetryFactor, HalfAxial=HalfAxial, InfoCore=3)
motion:
  MotionSetup1: Band Move_Type=Rotate Coordinate_System=Global Axis=Z Is_Positive=true InitPos=InitialPositionMD Angular_Velocity=-MachineRPM Objects=Rotating_Band
  Moving1: Moving Objects=[Rotor_1, Rotor_Pocket_1_8, L1_1Magnet1N1_1_1, L1_1Magnet2N1_1_1, Rotor_Pocket_1_14, Shaft, L1_1Magnet1N1_1_6, L1_1Magnet1N1_1_5, L1_1Magnet1N1_1_4, L1_1Magnet1N1_1_3, L1_1Magnet1N1_1_2, L1_1Magnet2N1_1_6, L1_1Magnet2N1_1_5, L1_1Magnet2N1_1_4, L1_1Magnet2N1_1_3, L1_1Magnet2N1_1_2]
boundaries and excitations:
  Independent1: Independent Objects=Boundary_Independent CoordSysVector{(0, 0, 60.557742) -> (99, 0, 60.557742)}
  Dependent1: Dependent Objects=Boundary_Dependent CoordSysVector{(0, 0, 60.557742) -> (70.003571, 70.003571, 60.557742)} Independent=Independent1 RelationIsSame=false
  CT_Ph1_P2_C1: Coil Terminal Objects=Ph1_P2_C1_Terminal Conductor_number=6 Winding=WG_Ph1_P1 Point_out_of_terminal=false
  CT_Ph2_P2_C1: Coil Terminal Objects=Ph2_P2_C1_Terminal Conductor_number=6 Winding=WG_Ph2_P1 Point_out_of_terminal=true
  CT_Ph3_P1_C1: Coil Terminal Objects=Ph3_P1_C1_Terminal Conductor_number=6 Winding=WG_Ph3_P1 Point_out_of_terminal=false
  WG_Ph1_P1: Winding Group Type=Current IsSolid=false Current="IPeak * sin((pi * MachineRPM/1rpm*NumPoles / 60*time + (360 - 0) / 360 * 2 * pi) + PhaseAdvance )" ParallelBranchesNum=ParallelPaths
  WG_Ph2_P1: Winding Group Type=Current IsSolid=false Current="IPeak * sin((pi * MachineRPM/1rpm*NumPoles / 60*time + (360 - 120) / 360 * 2 * pi) + PhaseAdvance )" ParallelBranchesNum=ParallelPaths
  WG_Ph3_P1: Winding Group Type=Current IsSolid=false Current="IPeak * sin((pi * MachineRPM/1rpm*NumPoles / 60*time + (360 - 240) / 360 * 2 * pi) + PhaseAdvance )" ParallelBranchesNum=ParallelPaths
  eddy effects on: L1_1Magnet1N1_1_1..L1_1Magnet1N1_1_6, L1_1Magnet2N1_1_1..L1_1Magnet2N1_1_6
  core loss on: Stator_Lamination_Primitive, Rotor_1
mesh:
  CylindricalGap1: CylindricalGap Objects=Rotating_Band BandMappingAngle=3deg MovingSideLayers=1 StaticSideLayers=1 Objects=Rotating_Band
temperatures:
  Stator_Lamination_Primitive, Rotor_1, Rotor_Pocket_1_8, Rotor_Pocket_1_14, Shaft, Ph1_P2_C1, Ph2_P2_C1, Ph2_P2_C2, Ph3_P1_C1, Ph3_P1_C2, Ph1_P2_C1_Terminal, Ph2_P2_C1_Terminal, Ph3_P1_C1_Terminal, Rotating_Band, Whole_Region, Boundary_Independent, Boundary_Dependent: 22cel
  L1_1Magnet1N1_1_1, L1_1Magnet2N1_1_1, L1_1Magnet1N1_1_3, L1_1Magnet1N1_1_2, L1_1Magnet2N1_1_3, L1_1Magnet2N1_1_2: 139.999983577095cel
setups:
  Setup1: Transient NonlinearSolverResidual=0.005 ScalarPotential="Second Order" StopTime="NumTorqueCycles * 120 / (MachineRPM / 1rpm * NumPoles) s" TimeStep="120 / (MachineRPM / 1rpm * NumPoles) / NumTorquePointsPerCycle s" OutputPerObjectCoreLoss SaveFieldsType="Every N Steps" N_Steps=6 Steps_From=0s Steps_To=(NumTorqueCycles*120)/(MachineRPM/1rpm*NumPoles) NumberSolveSteps=1 RangeStart=0s RangeEnd=0.1s
output variables:
  ThetaED = ((pi * MachineRPM/1rpm*NumPoles / 60*time + (360 - 0) / 360 * 2 * pi)) + pi
  Id_peak = 2/3*(InputCurrent(WG_Ph1_P1)*cos(ThetaED + 360deg)+InputCurrent(WG_Ph2_P1)*cos(ThetaED + 240deg)+InputCurrent(WG_Ph3_P1)*cos(ThetaED + 120deg))
  Iq_peak = 2/3*(InputCurrent(WG_Ph1_P1)*-sin(ThetaED + 360deg)+InputCurrent(WG_Ph2_P1)*-sin(ThetaED + 240deg)+InputCurrent(WG_Ph3_P1)*-sin(ThetaED + 120deg))
  PsiD = 2/3*(FluxLinkage(WG_Ph1_P1)*cos(ThetaED + 360deg)+FluxLinkage(WG_Ph2_P1)*cos(ThetaED + 240deg)+FluxLinkage(WG_Ph3_P1)*cos(ThetaED + 120deg))
  PsiQ = 2/3*(FluxLinkage(WG_Ph1_P1)*-sin(ThetaED + 360deg)+FluxLinkage(WG_Ph2_P1)*-sin(ThetaED + 240deg)+FluxLinkage(WG_Ph3_P1)*-sin(ThetaED + 120deg))
  TorqueDQ = 3/2*NumPoles/2*(PsiD*Iq_peak - PsiQ*Id_peak)
reports:
  Induced Voltage Plots: InducedVoltage(WG_Ph1_P1), InducedVoltage(WG_Ph2_P1), InducedVoltage(WG_Ph3_P1) vs Time on Setup1 : Transient
  Drive Current Plots: InputCurrent(WG_Ph1_P1), InputCurrent(WG_Ph2_P1), InputCurrent(WG_Ph3_P1), Id_peak, Iq_peak vs Time on Setup1 : Transient
  Flux Linkage Plots: FluxLinkage(WG_Ph1_P1), FluxLinkage(WG_Ph2_P1), FluxLinkage(WG_Ph3_P1), PsiD, PsiQ vs Time on Setup1 : Transient
  Torque Plots: -Moving1.Torque, TorqueDQ vs Time on Setup1 : Transient
