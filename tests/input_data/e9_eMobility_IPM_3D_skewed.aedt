# Ansys Electronics Desktop project, version 2025.1
materials:
  vacuum: permittivity=1
  M250-35A_20C: permeability{HUnit=A_per_meter BUnit=tesla curve (0, 0) (12, 0.1) (24, 0.2) (36, 0.3) (48, 0.4) (60, 0.5) (72, 0.6) (84, 0.7) (96, 0.8) (109, 0.9) (128, 1) (155, 1.1) (200, 1.2) (295, 1.3) (578, 1.4) (1567, 1.5) (3673, 1.6) (6996, 1.7) (13134.9088, 1.8162) (28200.2369, 1.8924) (100790, 1.998) (180370, 2.1) (259950, 2.2) (339530, 2.3) (419110, 2.4) (498690, 2.5)} conductivity=1694915.3 core_loss_type="Electrical Steel" core_loss_kh=187.425 core_loss_kc=0.34153292 mass_density=7650 stacking_type=Lamination stacking_factor=0.97 stacking_direction=V(3)
  Copper (Pure)_65C: conductivity=49416540
  N30UH_65C: permeability{BTypeForSingleCurve=intrinsic HUnit=A_per_meter BUnit=tesla curve (-1573592.5, 0) (-1573224.1, 0.021127765) (-1572847.1, 0.042272535) (-1572461.2, 0.063423273) (-1572066.3, 0.084568675) (-1571662.2, 0.10569718) (-1571248.6, 0.126797) (-1570825.3, 0.14785609) (-1570392.2, 0.16886221) (-1569948.8, 0.18980295) (-1569495.1, 0.2106657) (-1569030.8, 0.23143768) (-1568555.6, 0.25210601) (-1568069.3, 0.2726577) (-1567571.6, 0.29307963) (-1567062.2, 0.31335868) (-1566540.9, 0.33348165) (-1566007.5, 0.35343535) (-1565461.5, 0.37320661) (-1564902.7, 0.39278232) (-1564330.9, 0.41214945) (-1563745.7, 0.43129508) (-1563146.7, 0.45020645) (-1562533.8, 0.46887098) (-1561906.5, 0.4872763) (-1561264.5, 0.5054103) (-1560607.5, 0.52326116) (-1559935.1, 0.54081737) (-1559246.9, 0.55806779) (-1558542.7, 0.57500168) (-1557822, 0.59160871) (-1557084.3, 0.60787904) (-1556329.5, 0.62380331) (-1555556.9, 0.63937269) (-1554766.3, 0.65457894) (-1553957.1, 0.66941438) (-1553129, 0.68387199) (-1552281.6, 0.69794538) (-1551414.2, 0.71162884) (-1550526.6, 0.72491738) (-1549618.2, 0.73780672) (-1548688.5, 0.75029332) (-1547737.1, 0.76237442) (-1546763.4, 0.77404803) (-1545766.9, 0.78531292) (-1544747, 0.79616867) (-1543703.3, 0.80661567) (-1542635.2, 0.81665509) (-1541542, 0.82628888) (-1540423.3, 0.83551981) (-1539278.3, 0.84435139) (-1538106.6, 0.85278791) (-1536907.4, 0.86083441) (-1535680.2, 0.86849664) (-1534424.2, 0.87578105) (-1533138.8, 0.88269475) (-1531823.3, 0.88924551) (-1530477.1, 0.89544167) (-1529099.3, 0.90129215) (-1527689.2, 0.90680639) (-1526246.1, 0.91199429) (-1524769.3, 0.91686621) (-1523257.9, 0.92143287) (-1521711.1, 0.92570533) (-1520128.1, 0.92969492) (-1518508, 0.93341322) (-1516850, 0.93687197) (-1515153.2, 0.94008305) (-1513416.6, 0.94305841) (-1511639.4, 0.94581001) (-1509820.6, 0.94834979) (-1507959.2, 0.95068961) (-1506054.2, 0.9528412) (-1504104.7, 0.95481613) (-1502109.5, 0.95662576) (-1500067.6, 0.95828118) (-1497977.8, 0.9597932) (-1495839.2, 0.96117232) (-1493650.5, 0.96242867) (-1491410.5, 0.96357201) (-1489118.1, 0.96461171) (-1486772.1, 0.9655567) (-1484371.1, 0.96641549) (-1481913.9, 0.96719616) (-1479399.1, 0.96790631) (-1476825.5, 0.96855311) (-1474191.7, 0.96914328) (-1471496.2, 0.96968306) (-1468737.6, 0.97017827) (-1465914.4, 0.9706343) (-1463025.1, 0.97105611) (-1460068.1, 0.97144825) (-1457042, 0.97181489) (-1453945, 0.9721598) (-1450775.4, 0.97248644) (-1447531.7, 0.97279789) (-1444212.1, 0.97309695) (-1440814.7, 0.97338612) (-1437337.8, 0.97366763) (-1433779.5, 0.97394345) (-1430137.8, 0.97421535) (-1426411, 0.97448487) (-1422596.8, 0.97475338) (-1418693.4, 0.97502207) (-1414698.6, 0.97529199) (-1410610.3, 0.97556407) (-1406426.2, 0.9758391) (-1402144.2, 0.97611778) (-1397762, 0.97640073) (-1393277.2, 0.97668849) (-1388687.3, 0.97698153) (-1383990, 0.97728027) (-1379182.8, 0.9775851) (-1374263, 0.97789634) (-1369228, 0.9782143) (-1364075.1, 0.97853928) (-1358801.6, 0.97887153) (-1353404.7, 0.97921131) (-1347881.4, 0.97955885) (-1342228.7, 0.97991438)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} conductivity=555555.56 magnetic_coercivity{Magnitude=-1573592.5A_per_meter DirComp1=1 DirComp2=0 DirComp3=0}

design e9 (Maxwell 3D, Transient, model units mm)
variables:
  DiaGap = 132mm
  DiaStatorYoke = 198mm
  DiaShaft = 80mm
  DiaShaft_Effective = 80mm
  DiaOuter = 198mm
  Airgap = 1mm
  StatorSkewAngle = 0deg
  Model_Length = 255.42977mm
  Magnet_Length = 150mm
  Stator_Lam_Length = 160mm
  Rotor_Lam_Length = 150mm
  RotorDia = 130mm
  Rotor_Slices = 1
  SlotNumber_Stator = 48
  SlotType_Stator = 3
  Hs0_Stator = 1mm
  Hs1_Stator = 0.33497334mm
  Hs2_Stator = 17.541151mm
  Bs0_Stator = 3mm
  Bs1_Stator = 4.3148444mm
  Bs2_Stator = 6.61426mm
  Rs_Stator = 2mm
  FilletType_Stator = 3
  EndWindingLength = 60.429768mm
  Layers = 1
  ParallelPaths = 2
  SpanExt = 25.214884mm
  WdgExt_Avg = 5mm
  HalfAxial = 0
  SymmetryFactor = 8
  SegAngle = 0deg
  SegAngle_Coil_Armature = 10deg
  NumPoles = 8
  Magnet_Axial_Offset = 0mm
  Axial_Segments = 1
  PoleType_VPMCore = 1
  L1_ThicknessDuct = 6.2mm
  L1_WidthDuct = 17mm
  L1_ThicknessBridge = 1mm
  L1_ExtOuter = 2mm
  L1_ExtInner = 2mm
  L1_PoleVAngle = 150deg
  L1_ArcPole = 155deg
  L1_ThicknessPost = 0.5mm
  L1_DminMag = 4.5631061mm
  L1_WidthMagnet = 16mm
  L1_InnerGapMagnet = 0.2mm
  Shaft_Hole_Diameter = 0mm
  Sleeve_Thickness = 0mm
  Banding_Thickness = 0mm
  IPeak = 433A
  PhaseAdvance = 65.79deg
  MachineRPM = 100rpm
  NumTorqueCycles = 1
  NumTorquePointsPerCycle = 2
  DriveOffsetED = 0deg
  InitialPositionMD = -DriveOffsetED / (NumPoles/2)
geometry:
  Stator_Lamination_Primitive [M250-35A_20C] = user_primitive(RMxprt/VentSlotCore.dll, DiaGap=DiaGap, DiaYoke=DiaStatorYoke, Length=Stator_Lam_Length, Skew=StatorSkewAngle, Slots=SlotNumber_Stator, SlotType=SlotType_Stator, Hs0=Hs0_Stator, Hs01=0mm, Hs1=Hs1_Stator, Hs2=17.541151mm, Bs0=Bs0_Stator, Bs1=4.3148444mm, Bs2=6.61426mm, Rs=Rs_Stator, FilletType=FilletType_Stator, HalfSlot=0, VentHoles=0, HoleDiaIn=0mm, HoleDiaOut=0mm, HoleLocIn=0mm, HoleLocOut=0mm, VentDucts=0, DuctWidth=0mm, DuctPitch=0mm, SegAngle=SegAngle, LenRegion=0mm, InfoCore=0)
  Rotor_1 [M250-35A_20C] = circle(normal=Z, centre=(0mm, 0mm, 0mm), radius=65mm)
  Rotor_Subtract_12 = circle(normal=Z, centre=(0mm, 0mm, 0mm), radius=40mm)
  Rotor_1.subtract(Rotor_Subtract_12)
  Rotor_Pocket_1_8 [vacuum] = polyline(z=0mm, xy in mm: (48.6318, 16.2656) (58.372, 3.572) (58.6764, 3.1753) (62.3533, 3.4757) (63.5952, 6.9496) (63.2908, 7.3463) (53.5506, 20.0399) (53.2462, 20.4366) (49.5693, 20.1362) (48.3274, 16.6623) (48.6318, 16.2656), closed, covered, Arc from point 2 over 3, Arc from point 7 over 3)
  coordinate_system CS_L1_1Magnet1N1_1_1_RefToGlobal = origin=(56.04069mm, 11.866879mm, 0mm) Euler Angle ZYZ phi=-52.5deg theta=0deg psi=90deg
  L1_1Magnet1N1_1_1 [N30UH_65C, oriented by CS_L1_1Magnet1N1_1_1_RefToGlobal] = polyline(z=0mm, xy in mm: (58.5307, 3.6937) (63.2908, 7.3463) (53.5506, 20.0399) (48.7905, 16.3874) (58.5307, 3.6937), closed, covered)
  Rotor_Pocket_1_14 [vacuum] = polyline(z=0mm, xy in mm: (43.801, 38.7494) (45.8894, 22.8863) (45.9547, 22.3906) (49.2892, 20.8123) (52.1017, 23.1998) (52.0364, 23.6956) (49.948, 39.5587) (49.8827, 40.0544) (46.5482, 41.6327) (43.7358, 39.2451) (43.801, 38.7494), closed, covered, Arc from point 2 over 3, Arc from point 7 over 3)
  coordinate_system CS_L1_1Magnet2N1_1_1_RefToGlobal = origin=(48.017903mm, 31.235601mm, 0mm) Euler Angle ZYZ phi=-82.5deg theta=0deg psi=90deg
  L1_1Magnet2N1_1_1 [N30UH_65C, oriented by CS_L1_1Magnet2N1_1_1_RefToGlobal] = polyline(z=0mm, xy in mm: (49.948, 39.5587) (43.9993, 38.7755) (46.0877, 22.9124) (52.0364, 23.6956) (49.948, 39.5587), closed, covered)
  Shaft [vacuum] = circle(normal=Z, centre=(0mm, 0mm, 0mm), radius=40mm)
  Rotor_1.move(0mm, 0mm, 75mm)
  Rotor_1.sweep_along_vector((0mm, 0mm, -150mm))
  Shaft.move(0mm, 0mm, -75mm)
  Shaft.sweep_along_vector((0mm, 0mm, 150mm))
  Rotor_Pocket_1_8.move(0mm, 0mm, 75mm)
  Rotor_Pocket_1_8.sweep_along_vector((0mm, 0mm, -150mm))
  Rotor_Pocket_1_14.move(0mm, 0mm, 75mm)
  Rotor_Pocket_1_14.sweep_along_vector((0mm, 0mm, -150mm))
  Ph1_P2_C1 [Copper (Pure)_65C] = user_primitive(RMxprt/LapCoil.dll, DiaGap=132mm, DiaYoke=DiaStatorYoke, Length=Stator_Lam_Length, Skew=StatorSkewAngle, Slots=SlotNumber_Stator, SlotType=SlotType_Stator, Hs0=Hs0_Stator, Hs1=Hs1_Stator, Hs2=17.541151mm, Bs0=Bs0_Stator, Bs1=4.3148444mm, Bs2=6.61426mm, Rs=Rs_Stator, FilletType=FilletType_Stator, Layers=Layers, CoilPitch=5, EndExt=WdgExt_Avg, SpanExt=SpanExt, BendAngle=0deg, SegAngle=SegAngle_Coil_Armature, LenRegion=Model_Length, InfoCoil=1)
  Ph1_P2_C1.rotate(axis=Z, angle=0deg)
  Ph2_P2_C1 [Copper (Pure)_65C] = user_primitive(RMxprt/LapCoil.dll, DiaGap=132mm, DiaYoke=DiaStatorYoke, Length=Stator_Lam_Length, Skew=StatorSkewAngle, Slots=SlotNumber_Stator, SlotType=SlotType_Stator, Hs0=Hs0_Stator, Hs1=Hs1_Stator, Hs2=17.541151mm, Bs0=Bs0_Stator, Bs1=4.3148444mm, Bs2=6.61426mm, Rs=Rs_Stator, FilletType=FilletType_Stator, Layers=Layers, CoilPitch=5, EndExt=WdgExt_Avg, SpanExt=SpanExt, BendAngle=0deg, SegAngle=SegAngle_Coil_Armature, LenRegion=Model_Length, InfoCoil=1)
  Ph2_P2_C1.rotate(axis=Z, angle=15deg)
  Ph2_P2_C2 [Copper (Pure)_65C] = user_primitive(RMxprt/LapCoil.dll, DiaGap=132mm, DiaYoke=DiaStatorYoke, Length=Stator_Lam_Length, Skew=StatorSkewAngle, Slots=SlotNumber_Stator, SlotType=SlotType_Stator, Hs0=Hs0_Stator, Hs1=Hs1_Stator, Hs2=17.541151mm, Bs0=Bs0_Stator, Bs1=4.3148444mm, Bs2=6.61426mm, Rs=Rs_Stator, FilletType=FilletType_Stator, Layers=Layers, CoilPitch=5, EndExt=WdgExt_Avg, SpanExt=SpanExt, BendAngle=0deg, SegAngle=SegAngle_Coil_Armature, LenRegion=Model_Length, InfoCoil=1)
  Ph2_P2_C2.rotate(axis=Z, angle=330deg)
  Ph3_P1_C1 [Copper (Pure)_65C] = user_primitive(RMxprt/LapCoil.dll, DiaGap=132mm, DiaYoke=DiaStatorYoke, Length=Stator_Lam_Length, Skew=StatorSkewAngle, Slots=SlotNumber_Stator, SlotType=SlotType_Stator, Hs0=Hs0_Stator, Hs1=Hs1_Stator, Hs2=17.541151mm, Bs0=Bs0_Stator, Bs1=4.3148444mm, Bs2=6.61426mm, Rs=Rs_Stator, FilletType=FilletType_Stator, Layers=Layers, CoilPitch=5, EndExt=WdgExt_Avg, SpanExt=SpanExt, BendAngle=0deg, SegAngle=SegAngle_Coil_Armature, LenRegion=Model_Length, InfoCoil=1)
  Ph3_P1_C1.rotate(axis=Z, angle=30deg)
  Ph3_P1_C2 [Copper (Pure)_65C] = user_primitive(RMxprt/LapCoil.dll, DiaGap=132mm, DiaYoke=DiaStatorYoke, Length=Stator_Lam_Length, Skew=StatorSkewAngle, Slots=SlotNumber_Stator, SlotType=SlotType_Stator, Hs0=Hs0_Stator, Hs1=Hs1_Stator, Hs2=17.541151mm, Bs0=Bs0_Stator, Bs1=4.3148444mm, Bs2=6.61426mm, Rs=Rs_Stator, FilletType=FilletType_Stator, Layers=Layers, CoilPitch=5, EndExt=WdgExt_Avg, SpanExt=SpanExt, BendAngle=0deg, SegAngle=SegAngle_Coil_Armature, LenRegion=Model_Length, InfoCoil=1)
  Ph3_P1_C2.rotate(axis=Z, angle=345deg)
  coordinate_system PhTerminal_CS = origin=(0mm, 0mm, Stator_Lam_Length/2) Euler Angle ZYZ phi=StatorSkewAngle/2 theta=0deg psi=0deg
  Ph1_P2_C1_Terminal [Copper (Pure)_65C] = user_primitive(RMxprt/LapCoil.dll, DiaGap=132mm, DiaYoke=DiaStatorYoke, Length=Stator_Lam_Length, Skew=StatorSkewAngle, Slots=SlotNumber_Stator, SlotType=SlotType_Stator, Hs0=Hs0_Stator, Hs1=Hs1_Stator, Hs2=17.541151mm, Bs0=Bs0_Stator, Bs1=4.3148444mm, Bs2=6.61426mm, Rs=Rs_Stator, FilletType=FilletType_Stator, Layers=Layers, CoilPitch=5, EndExt=WdgExt_Avg, SpanExt=SpanExt, BendAngle=0deg, SegAngle=SegAngle_Coil_Armature, LenRegion=Model_Length, InfoCoil=2) in PhTerminal_CS
  Ph1_P2_C1_Terminal.rotate(axis=Z, angle=0deg) in PhTerminal_CS
  Ph2_P2_C1_Terminal [Copper (Pure)_65C] = user_primitive(RMxprt/LapCoil.dll, DiaGap=132mm, DiaYoke=DiaStatorYoke, Length=Stator_Lam_Length, Skew=StatorSkewAngle, Slots=SlotNumber_Stator, SlotType=SlotType_Stator, Hs0=Hs0_Stator, Hs1=Hs1_Stator, Hs2=17.541151mm, Bs0=Bs0_Stator, Bs1=4.3148444mm, Bs2=6.61426mm, Rs=Rs_Stator, FilletType=FilletType_Stator, Layers=Layers, CoilPitch=5, EndExt=WdgExt_Avg, SpanExt=SpanExt, BendAngle=0deg, SegAngle=SegAngle_Coil_Armature, LenRegion=Model_Length, InfoCoil=2) in PhTerminal_CS
  Ph2_P2_C1_Terminal.rotate(axis=Z, angle=15deg) in PhTerminal_CS
  Ph3_P1_C1_Terminal [Copper (Pure)_65C] = user_primitive(RMxprt/LapCoil.dll, DiaGap=132mm, DiaYoke=DiaStatorYoke, Length=Stator_Lam_Length, Skew=StatorSkewAngle, Slots=SlotNumber_Stator, SlotType=SlotType_Stator, Hs0=Hs0_Stator, Hs1=Hs1_Stator, Hs2=17.541151mm, Bs0=Bs0_Stator, Bs1=4.3148444mm, Bs2=6.61426mm, Rs=Rs_Stator, FilletType=FilletType_Stator, Layers=Layers, CoilPitch=5, EndExt=WdgExt_Avg, SpanExt=SpanExt, BendAngle=0deg, SegAngle=SegAngle_Coil_Armature, LenRegion=Model_Length, InfoCoil=2) in PhTerminal_CS
  Ph3_P1_C1_Terminal.rotate(axis=Z, angle=30deg) in PhTerminal_CS
  L1_1Magnet1N1_1_1.move(0mm, 0mm, Magnet_Length/2+Magnet_Axial_Offset) in PhTerminal_CS
  L1_1Magnet1N1_1_1.sweep_along_vector((0mm, 0mm, -150mm)) in PhTerminal_CS
  L1_1Magnet2N1_1_1.move(0mm, 0mm, Magnet_Length/2+Magnet_Axial_Offset) in PhTerminal_CS
  L1_1Magnet2N1_1_1.sweep_along_vector((0mm, 0mm, -150mm)) in PhTerminal_CS
  coordinate_system CS_L1_1Magnet1N3_1_1 = origin=(-56.04069mm, -11.866879mm, (Magnet_Length / 2) + Magnet_Axial_Offset - 75mm) x=(-0.84432629mm, -0.64787435mm, 0mm) y=(0.64787435mm, -0.84432629mm, 0mm)
  coordinate_system CS_L1_1Magnet1S3_1_1 = origin=(-48.017903mm, 31.235601mm, (Magnet_Length / 2) + Magnet_Axial_Offset - 75mm) x=(1.0551452mm, -0.1389125mm, 0mm) y=(0.1389125mm, 1.0551452mm, 0mm)
  coordinate_system CS_L1_1Magnet1S4_1_1 = origin=(-31.235601mm, -48.017903mm, (Magnet_Length / 2) + Magnet_Axial_Offset - 75mm) x=(0.1389125mm, 1.0551452mm, 0mm) y=(-1.0551452mm, 0.1389125mm, 0mm)
  coordinate_system CS_L1_1Magnet1N2_1_1 = origin=(-11.866879mm, 56.04069mm, (Magnet_Length / 2) + Magnet_Axial_Offset - 75mm) x=(-0.64787435mm, 0.84432629mm, 0mm) y=(-0.84432629mm, -0.64787435mm, 0mm)
  coordinate_system CS_L1_1Magnet1N4_1_1 = origin=(11.866879mm, -56.04069mm, (Magnet_Length / 2) + Magnet_Axial_Offset - 75mm) x=(0.64787435mm, -0.84432629mm, 0mm) y=(0.84432629mm, 0.64787435mm, 0mm)
  coordinate_system CS_L1_1Magnet1S2_1_1 = origin=(31.235601mm, 48.017903mm, (Magnet_Length / 2) + Magnet_Axial_Offset - 75mm) x=(-0.1389125mm, -1.0551452mm, 0mm) y=(1.0551452mm, -0.1389125mm, 0mm)
  coordinate_system CS_L1_1Magnet1S1_1_1 = origin=(48.017903mm, -31.235601mm, (Magnet_Length / 2) + Magnet_Axial_Offset - 75mm) x=(-1.0551452mm, 0.1389125mm, 0mm) y=(-0.1389125mm, -1.0551452mm, 0mm)
  coordinate_system CS_L1_1Magnet1N1_1_1 = origin=(56.04069mm, 11.866879mm, (Magnet_Length / 2) + Magnet_Axial_Offset - 75mm) x=(0.84432629mm, 0.64787435mm, 0mm) y=(-0.64787435mm, 0.84432629mm, 0mm)
  coordinate_system CS_L1_1Magnet2S3_1_1 = origin=(-56.04069mm, 11.866879mm, (Magnet_Length / 2) + Magnet_Axial_Offset - 75mm) x=(0.84432629mm, -0.64787435mm, 0mm) y=(0.64787435mm, 0.84432629mm, 0mm)
  coordinate_system CS_L1_1Magnet2N3_1_1 = origin=(-48.017903mm, -31.235601mm, (Magnet_Length / 2) + Magnet_Axial_Offset - 75mm) x=(-1.0551452mm, -0.1389125mm, 0mm) y=(0.1389125mm, -1.0551452mm, 0mm)
  coordinate_system CS_L1_1Magnet2N2_1_1 = origin=(-31.235601mm, 48.017903mm, (Magnet_Length / 2) + Magnet_Axial_Offset - 75mm) x=(-0.1389125mm, 1.0551452mm, 0mm) y=(-1.0551452mm, -0.1389125mm, 0mm)
  coordinate_system CS_L1_1Magnet2S4_1_1 = origin=(-11.866879mm, -56.04069mm, (Magnet_Length / 2) + Magnet_Axial_Offset - 75mm) x=(0.64787435mm, 0.84432629mm, 0mm) y=(-0.84432629mm, 0.64787435mm, 0mm)
  coordinate_system CS_L1_1Magnet2S2_1_1 = origin=(11.866879mm, 56.04069mm, (Magnet_Length / 2) + Magnet_Axial_Offset - 75mm) x=(-0.64787435mm, -0.84432629mm, 0mm) y=(0.84432629mm, -0.64787435mm, 0mm)
  coordinate_system CS_L1_1Magnet2N4_1_1 = origin=(31.235601mm, -48.017903mm, (Magnet_Length / 2) + Magnet_Axial_Offset - 75mm) x=(0.1389125mm, -1.0551452mm, 0mm) y=(1.0551452mm, 0.1389125mm, 0mm)
  coordinate_system CS_L1_1Magnet2N1_1_1 = origin=(48.017903mm, 31.235601mm, (Magnet_Length / 2) + Magnet_Axial_Offset - 75mm) x=(1.0551452mm, 0.1389125mm, 0mm) y=(-0.1389125mm, 1.0551452mm, 0mm)
  coordinate_system CS_L1_1Magnet2S1_1_1 = origin=(56.04069mm, -11.866879mm, (Magnet_Length / 2) + Magnet_Axial_Offset - 75mm) x=(-0.84432629mm, 0.64787435mm, 0mm) y=(-0.64787435mm, -0.84432629mm, 0mm)
  Rotating_Band [vacuum] = user_primitive(RMxprt/Band.dll, DiaGap=DiaGap - (2 * (Airgap - Banding_Thickness)) + (4 * ((airgap - Banding_Thickness - Sleeve_Thickness) / 4)), DiaYoke=Shaft_Hole_Diameter, Length=233.00312mm, SegAngle=0deg, Fractions=SymmetryFactor, HalfAxial=HalfAxial, InfoCore=0)
  Band_Tool = user_primitive(RMxprt/Band.dll, DiaGap=1mm, DiaYoke=DiaOuter, Length=233.00312mm, SegAngle=SegAngle, Fractions=SymmetryFactor, HalfAxial=HalfAxial, InfoCore=1)
  Whole_Region [vacuum] = user_primitive(RMxprt/Band.dll, DiaGap=DiaGap+Airgap, DiaYoke=DiaOuter, Length=233.00312mm, SegAngle=SegAngle, Fractions=SymmetryFactor, HalfAxial=HalfAxial, InfoCore=100)
  Band_Tool_1 = Band_Tool.copy()
  Stator_Lamination_Primitive.subtract(Band_Tool_1)
  Band_Tool_2 = Band_Tool.copy()
  Rotor_1.subtract(Band_Tool_2)
  Band_Tool_19 = Band_Tool.copy()
  Rotor_Pocket_1_8.subtract(Band_Tool_19)
  Band_Tool_20 = Band_Tool.copy()
  L1_1Magnet1N1_1_1.subtract(Band_Tool_20)
  Band_Tool_31 = Band_Tool.copy()
  Rotor_Pocket_1_14.subtract(Band_Tool_31)
  Band_Tool_32 = Band_Tool.copy()
  L1_1Magnet2N1_1_1.subtract(Band_Tool_32)
  Band_Tool_35 = Band_Tool.copy()
  Shaft.subtract(Band_Tool_35)
  Band_Tool_36 = Band_Tool.copy()
  Ph1_P2_C1.subtract(Band_Tool_36)
  Band_Tool_37 = Band_Tool.copy()
  Ph2_P2_C1.subtract(Band_Tool_37)
  Band_Tool_38 = Band_Tool.copy()
  Ph2_P2_C2.subtract(Band_Tool_38)
  Band_Tool_39 = Band_Tool.copy()
  Ph3_P1_C1.subtract(Band_Tool_39)
  Band_Tool_40 = Band_Tool.copy()
  Ph3_P1_C2.subtract(Band_Tool_40)
  Band_Tool_41 = Band_Tool.copy()
  Ph1_P2_C1_Terminal.subtract(Band_Tool_41)
  Band_Tool_42 = Band_Tool.copy()
  Ph2_P2_C1_Terminal.subtract(Band_Tool_42)
  Band_Tool_43 = Band_Tool.copy()
  Ph3_P1_C1_Terminal.subtract(Band_Tool_43)
  Band_Tool_44 = Band_Tool.copy()
  Rotating_Band.subtract(Band_Tool_44)
  Whole_Region.subtract(Band_Tool)
  Boundary_Independent [vacuum] = user_primitive(RMxprt/Band.dll, DiaGap=DiaGap+Airgap, DiaYoke=DiaOuter, Length=233.00312mm, SegAngle=SegAngle, Fractions=SymmetryFactor, HalfAxial=HalfAxial, InfoCore=2)
  Boundary_Dependent [vacuum] = user_primitive(RMxprt/Band.dll, DiaGap=DiaGap+Airgap, DiaYoke=DiaOuter, Length=233.00312mm, SegAngle=SegAngle, Fractions=SymmetryFactor, HalfAxial=HalfAxial, InfoCore=3)
  Rotor_1_ObjectFromFace1 = object_from(Rotor_1.face(at (46.6421, 23.1189, -75)))
  Rotor_1_ObjectFromFace1_1 = Rotor_1_ObjectFromFace1.duplicate_along_line(step=(0mm, 0mm, 75mm), total=2)
  Rotor_1_ObjectFromFace1.delete()
  Rotor_1_Split1 [M250-35A_20C] = Rotor_1.split(plane=Rotor_1_ObjectFromFace1_1_1.face, keep=Both)
  Rotor_1_ObjectFromFace1_1_1 = Rotor_1_ObjectFromFace1_1.copy()
  Rotor_1_ObjectFromFace1_1_1.delete()
  L1_1Magnet1N1_1_1_Split1 [N30UH_65C, oriented by CS_L1_1Magnet1N1_1_1_RefToGlobal_L7AWNW] = L1_1Magnet1N1_1_1.split(plane=Rotor_1_ObjectFromFace1_1_2.face, keep=Both)
  Rotor_1_ObjectFromFace1_1_2 = Rotor_1_ObjectFromFace1_1.copy()
  Rotor_1_ObjectFromFace1_1_2.delete()
  coordinate_system CS_L1_1Magnet1N1_1_1_RefToGlobal_L7AWNW = origin=(56.04069mm, 11.866879mm, 0mm) Euler Angle ZYZ phi=-52.5deg+2.0deg theta=0deg psi=90deg
  L1_1Magnet2N1_1_1_Split1 [N30UH_65C, oriented by CS_L1_1Magnet2N1_1_1_RefToGlobal_4A9R1X] = L1_1Magnet2N1_1_1.split(plane=Rotor_1_ObjectFromFace1_1_3.face, keep=Both)
  Rotor_1_ObjectFromFace1_1_3 = Rotor_1_ObjectFromFace1_1.copy()
  Rotor_1_ObjectFromFace1_1_3.delete()
  coordinate_system CS_L1_1Magnet2N1_1_1_RefToGlobal_4A9R1X = origin=(48.017903mm, 31.235601mm, 0mm) Euler Angle ZYZ phi=-82.5deg+2.0deg theta=0deg psi=90deg
  Rotor_Pocket_1_8_Split1 [vacuum] = Rotor_Pocket_1_8.split(plane=Rotor_1_ObjectFromFace1_1_4.face, keep=Both)
  Rotor_1_ObjectFromFace1_1_4 = Rotor_1_ObjectFromFace1_1.copy()
  Rotor_1_ObjectFromFace1_1_4.delete()
  Rotor_Pocket_1_14_Split1 [vacuum] = Rotor_Pocket_1_14.split(plane=Rotor_1_ObjectFromFace1_1_5.face, keep=Both)
  Rotor_1_ObjectFromFace1_1_5 = Rotor_1_ObjectFromFace1_1.copy()
  [Rotor_1_ObjectFromFace1_1, Rotor_1_ObjectFromFace1_1_5].delete()
  L1_1Magnet1N1_1_1_ObjectFromFace1 = object_from(L1_1Magnet1N1_1_1.face(at (56.0406, 11.8668, -75)))
  L1_1Magnet1N1_1_1_ObjectFromFace1_1 = L1_1Magnet1N1_1_1_ObjectFromFace1.duplicate_along_line(step=(0mm, 0mm, 37.5mm), total=2)
  L1_1Magnet1N1_1_1_ObjectFromFace1.delete()
  L1_1Magnet1N1_1_1_ObjectFromFace1_1_ObjectFromFace1 [N30UH_65C, oriented by CS_L1_1Magnet1N1_1_1_RefToGlobal] = object_from(L1_1Magnet1N1_1_1_ObjectFromFace1_1.face)
  L1_1Magnet1N1_1_1_ObjectFromFace1_1.delete()
  L1_1Magnet2N1_1_1_ObjectFromFace1 = object_from(L1_1Magnet2N1_1_1.face(at (48.0179, 31.2355, -75)))
  L1_1Magnet2N1_1_1_ObjectFromFace1_1 = L1_1Magnet2N1_1_1_ObjectFromFace1.duplicate_along_line(step=(0mm, 0mm, 37.5mm), total=2)
  L1_1Magnet2N1_1_1_ObjectFromFace1.delete()
  L1_1Magnet2N1_1_1_ObjectFromFace1_1_ObjectFromFace1 [N30UH_65C, oriented by CS_L1_1Magnet2N1_1_1_RefToGlobal] = object_from(L1_1Magnet2N1_1_1_ObjectFromFace1_1.face)
  L1_1Magnet2N1_1_1_ObjectFromFace1_1.delete()
  L1_1Magnet1N1_1_1_Split1_ObjectFromFace1 = object_from(L1_1Magnet1N1_1_1_Split1.face(at (56.0406, 11.8668, 0)))
  L1_1Magnet1N1_1_1_Split1_ObjectFromFace1_1 = L1_1Magnet1N1_1_1_Split1_ObjectFromFace1.duplicate_along_line(step=(0mm, 0mm, 37.5mm), total=2)
  L1_1Magnet1N1_1_1_Split1_ObjectFromFace1.delete()
  L1_1Magnet1N1_1_1_Split1_ObjectFromFace1_1_ObjectFromFace1 [N30UH_65C, oriented by CS_L1_1Magnet1N1_1_1_RefToGlobal_L7AWNW] = object_from(L1_1Magnet1N1_1_1_Split1_ObjectFromFace1_1.face)
  L1_1Magnet1N1_1_1_Split1_ObjectFromFace1_1.delete()
  L1_1Magnet2N1_1_1_Split1_ObjectFromFace1 = object_from(L1_1Magnet2N1_1_1_Split1.face(at (48.0179, 31.2355, 0)))
  L1_1Magnet2N1_1_1_Split1_ObjectFromFace1_1 = L1_1Magnet2N1_1_1_Split1_ObjectFromFace1.duplicate_along_line(step=(0mm, 0mm, 37.5mm), total=2)
  L1_1Magnet2N1_1_1_Split1_ObjectFromFace1.delete()
  L1_1Magnet2N1_1_1_Split1_ObjectFromFace1_1_ObjectFromFace1 [N30UH_65C, oriented by CS_L1_1Magnet2N1_1_1_RefToGlobal_4A9R1X] = object_from(L1_1Magnet2N1_1_1_Split1_ObjectFromFace1_1.face)
  L1_1Magnet2N1_1_1_Split1_ObjectFromFace1_1.delete()
  Rotor_1_Split1.rotate(axis=Z, angle=2deg)
  [L1_1Magnet1N1_1_1_Split1, L1_1Magnet2N1_1_1_Split1, Rotor_Pocket_1_8_Split1, Rotor_Pocket_1_14_Split1, Rotor_1_Split1].rotate(axis=Z, angle=2deg)
  Rotor_1_Split1_Split1 = Rotor_1_Split1.split(plane=Boundary_Dependent_1.face(1 of 1), keep=Both)
  Boundary_Dependent_1 = Boundary_Dependent.copy()
  Boundary_Dependent_1.delete()
  Rotor_1_Split1_Split1.rotate(axis=Z, angle=-45deg)
  Rotor_1_Split1.unite(Rotor_1_Split1_Split1)
motion:
  MotionSetup1: Band Move_Type=Rotate Coordinate_System=Global Axis=Z Is_Positive=true InitPos=InitialPositionMD Angular_Velocity=-MachineRPM Objects=Rotating_Band
  Moving1: Moving Objects=[Rotor_1, Rotor_Pocket_1_8, L1_1Magnet1N1_1_1, Rotor_Pocket_1_14, L1_1Magnet2N1_1_1, Shaft, Rotor_1_Split1, L1_1Magnet1N1_1_1_Split1, L1_1Magnet2N1_1_1_Split1, Rotor_Pocket_1_8_Split1, Rotor_Pocket_1_14_Split1, L1_1Magnet1N1_1_1_ObjectFromFace1_1_ObjectFromFace1, L1_1Magnet2N1_1_1_ObjectFromFace1_1_ObjectFromFace1, L1_1Magnet1N1_1_1_Split1_ObjectFromFace1_1_ObjectFromFace1, L1_1Magnet2N1_1_1_Split1_ObjectFromFace1_1_ObjectFromFace1]
boundaries and excitations:
  Independent1: Independent Objects=Boundary_Independent CoordSysVector{(0, 0, -116.50156) -> (99, 0, -116.50156)}
  Dependent1: Dependent Objects=Boundary_Dependent CoordSysVector{(0, 0, -116.50156) -> (70.003571, 70.003571, -116.50156)} Independent=Independent1 RelationIsSame=false
  L1_1Magnet1N1_1_1_segments: Insulating Faces=L1_1Magnet1N1_1_1_ObjectFromFace1_1_ObjectFromFace1.face
  L1_1Magnet2N1_1_1_segments: Insulating Faces=L1_1Magnet2N1_1_1_ObjectFromFace1_1_ObjectFromFace1.face
  L1_1Magnet1N1_1_1_Split1_segments: Insulating Faces=L1_1Magnet1N1_1_1_Split1_ObjectFromFace1_1_ObjectFromFace1.face
  L1_1Magnet2N1_1_1_Split1_segments: Insulating Faces=L1_1Magnet2N1_1_1_Split1_ObjectFromFace1_1_ObjectFromFace1.face
  CT_Ph1_P2_C1: Coil Terminal Objects=Ph1_P2_C1_Terminal Conductor_number=6 Winding=WG_Ph1_P1 Point_out_of_terminal=false
  CT_Ph2_P2_C1: Coil Terminal Objects=Ph2_P2_C1_Terminal Conductor_number=6 Winding=WG_Ph2_P1 Point_out_of_terminal=true
  CT_Ph3_P1_C1: Coil Terminal Objects=Ph3_P1_C1_Terminal Conductor_number=6 Winding=WG_Ph3_P1 Point_out_of_terminal=false
  WG_Ph1_P1: Winding Group Type=Current IsSolid=false Current="IPeak * sin((pi * MachineRPM/1rpm*NumPoles / 60*time + (360 - 0) / 360 * 2 * pi) + PhaseAdvance )" ParallelBranchesNum=ParallelPaths
  WG_Ph2_P1: Winding Group Type=Current IsSolid=false Current="IPeak * sin((pi * MachineRPM/1rpm*NumPoles / 60*time + (360 - 120) / 360 * 2 * pi) + PhaseAdvance )" ParallelBranchesNum=ParallelPaths
  WG_Ph3_P1: Winding Group Type=Current IsSolid=false Current="IPeak * sin((pi * MachineRPM/1rpm*NumPoles / 60*time + (360 - 240) / 360 * 2 * pi) + PhaseAdvance )" ParallelBranchesNum=ParallelPaths
  eddy effects on: L1_1Magnet1N1_1_1, L1_1Magnet2N1_1_1
  core loss on: Stator_Lamination_Primitive, Rotor_1
mesh:
  CylindricalGap1: CylindricalGap Objects=Rotating_Band BandMappingAngle=3deg MovingSideLayers=1 StaticSideLayers=1 Objects=Rotating_Band
temperatures:
  Stator_Lamination_Primitive, Rotor_1, Rotor_Pocket_1_8, Rotor_Pocket_1_14, Shaft, Ph1_P2_C1, Ph2_P2_C1, Ph2_P2_C2, Ph3_P1_C1, Ph3_P1_C2, Ph1_P2_C1_Terminal, Ph2_P2_C1_Terminal, Ph3_P1_C1_Terminal, Rotating_Band, Whole_Region, Boundary_Independent, Boundary_Dependent, Rotor_1_Split1, L1_1Magnet1N1_1_1_Split1, L1_1Magnet2N1_1_1_Split1, Rotor_Pocket_1_8_Split1, Rotor_Pocket_1_14_Split1, L1_1Magnet1N1_1_1_ObjectFromFace1_1_ObjectFromFace1, L1_1Magnet2N1_1_1_ObjectFromFace1_1_ObjectFromFace1, L1_1Magnet1N1_1_1_Split1_ObjectFromFace1_1_ObjectFromFace1, L1_1Magnet2N1_1_1_Split1_ObjectFromFace1_1_ObjectFromFace1: 22cel
  L1_1Magnet1N1_1_1, L1_1Magnet2N1_1_1: 65cel
setups:
  Setup1: Transient NonlinearSolverResidual=0.005 ScalarPotential="Second Order" StopTime="NumTorqueCycles * 120 / (MachineRPM / 1rpm * NumPoles)" TimeStep="120 / (MachineRPM / 1rpm * NumPoles) / NumTorquePointsPerCycle" OutputPerObjectCoreLoss SaveFieldsType="Every N Steps" N_Steps=6 Steps_From=0s Steps_To=(NumTorqueCycles*120)/(MachineRPM/1rpm*NumPoles) NumberSolveSteps=1 RangeStart=0s RangeEnd=0.1s
output variables:
  ThetaED = ((pi * MachineRPM/1rpm*NumPoles / 60*time + (360 - 0) / 360 * 2 * pi)) + pi
  Id_peak = 2/3*(InputCurrent(WG_Ph1_P1)*cos(ThetaED + 360deg)+InputCurrent(WG_Ph2_P1)*cos(ThetaED + 240deg)+InputCurrent(WG_Ph3_P1)*cos(ThetaED + 120deg))
  Iq_peak = 2/3*(InputCurrent(WG_Ph1_P1)*-sin(ThetaED + 360deg)+InputCurrent(WG_Ph2_P1)*-sin(ThetaED + 240deg)+InputCurrent(WG_Ph3_P1)*-sin(ThetaED + 120deg))
  PsiD = 2/3*(FluxLinkage(WG_Ph1_P1)*cos(ThetaED + 360deg)+FluxLinkage(WG_Ph2_P1)*cos(ThetaED + 240deg)+FluxLinkage(WG_Ph3_P1)*cos(ThetaED + 120deg))
  PsiQ = 2/3*(FluxLinkage(WG_Ph1_P1)*-sin(ThetaED + 360deg)+FluxLinkage(WG_Ph2_P1)*-sin(ThetaED + 240deg)+FluxLinkage(WG_Ph3_P1)*-sin(ThetaED + 120deg))
  TorqueDQ = 3/2*NumPoles/2*(PsiD*Iq_peak - PsiQ*Id_peak)
