# Ansys Electronics Desktop project, version 2025.2
materials:
  vacuum: permittivity=1
  copper: permeability=0.999991 conductivity=58000000

design Maxwell3DDesign1 (Maxwell 3D, Transient, model units mm)
geometry:
  Box1 [copper] = box(corner=(-0.4mm, -0.4mm, 0mm), size=(1mm, 1.2mm, 0.8mm))
  Region [vacuum] = region(percentage_offset: +X=50, -X=50, +Y=0, -Y=0, +Z=50, -Z=50)
boundaries and excitations:
  CoilTerminal1: Coil Terminal Faces=Box1.face(-y) Conductor_number=1 Winding=Winding1 Point_out_of_terminal=false
  CoilTerminal2: Coil Terminal Faces=Box1.face(+y) Conductor_number=1 Winding=Winding1 Point_out_of_terminal=true
  Winding1: Winding Group Type=Current IsSolid=true Current=1mA ParallelBranchesNum=1
mesh:
  initial mesh: GlobalCurvilinear{Apply}
setups:
  Setup1: Transient NonlinearSolverResidual=0.005 ScalarPotential="Second Order" StopTime=1ns TimeStep=0.5ns
